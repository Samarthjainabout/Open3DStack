************************************************************************
* auCdl Netlist:
*
* Library Name:  tft3d_sc_t5
* Top Cell Name: AND2_X1RL_T5
* View Name:     schematic
* Netlisted on:  Mar  3 13:34:18 2026
************************************************************************

*.EQUATION
*.SCALE METER
*.MEGA
.PARAM

************************************************************************
* Library Name: tft3d_sc_t5
* Cell Name:    AND2_X1RL_T5
* View Name:    schematic
************************************************************************

.SUBCKT AND2_X1RL_T5 A1 A2 VDD VSS Y
*.PININFO A1:I A2:I Y:O VDD:B VSS:B
RR1 VDD Y $[resmod] $W=600n $L=88.8u m=1 trise=0 ncorners=8 flg_local_she=-1
RR0 VDD YN $[resmod] $W=600n $L=93.8u m=1 trise=0 ncorners=13 flg_local_she=-1
MM2 Y YN VSS nch W=1u L=600n m=1 trise=0 flg_local_she=-1
MM0 YN A1 net1 nch W=1u L=600n m=1 trise=0 flg_local_she=-1
MM1 net1 A2 VSS nch W=1u L=600n m=1 trise=0 flg_local_she=-1
.ENDS

************************************************************************
* auCdl Netlist:
*
* Library Name:  tft3d_sc_t5
* Top Cell Name: AND2_X2RL_T5
* View Name:     schematic
* Netlisted on:  Mar  3 13:34:42 2026
************************************************************************

*.EQUATION
*.SCALE METER
*.MEGA
.PARAM

************************************************************************
* Library Name: tft3d_sc_t5
* Cell Name:    AND2_X2RL_T5
* View Name:    schematic
************************************************************************

.SUBCKT AND2_X2RL_T5 A1 A2 VDD VSS Y
*.PININFO A1:I A2:I Y:O VDD:B VSS:B
RR1 VDD Y $[resmod] $W=600n $L=44.5u m=1 trise=0 ncorners=4 flg_local_she=-1
RR0 VDD YN $[resmod] $W=600n $L=93.8u m=1 trise=0 ncorners=13 flg_local_she=-1
MM2 Y YN VSS nch W=1u L=600n m=1 trise=0 flg_local_she=-1
MM0 YN A1 net1 nch W=1u L=600n m=1 trise=0 flg_local_she=-1
MM1 net1 A2 VSS nch W=1u L=600n m=1 trise=0 flg_local_she=-1
.ENDS

************************************************************************
* auCdl Netlist:
*
* Library Name:  tft3d_sc_t5
* Top Cell Name: AND2_X4RL_T5
* View Name:     schematic
* Netlisted on:  Mar  3 13:34:42 2026
************************************************************************

*.EQUATION
*.SCALE METER
*.MEGA
.PARAM

************************************************************************
* Library Name: tft3d_sc_t5
* Cell Name:    AND2_X4RL_T5
* View Name:    schematic
************************************************************************

.SUBCKT AND2_X4RL_T5 A1 A2 VDD VSS Y
*.PININFO A1:I A2:I Y:O VDD:B VSS:B
RR1 VDD Y $[resmod] $W=600n $L=24.3u m=1 trise=0 ncorners=4 flg_local_she=-1
RR0 VDD YN $[resmod] $W=600n $L=93.8u m=1 trise=0 ncorners=13 flg_local_she=-1
MM2 Y YN VSS nch W=1u L=600n m=1 trise=0 flg_local_she=-1
MM0 YN A1 net1 nch W=1u L=600n m=1 trise=0 flg_local_she=-1
MM1 net1 A2 VSS nch W=1u L=600n m=1 trise=0 flg_local_she=-1
.ENDS

************************************************************************
* auCdl Netlist:
*
* Library Name:  tft3d_sc_t5
* Top Cell Name: AND3_X1RL_T5
* View Name:     schematic
* Netlisted on:  Mar  3 13:34:18 2026
************************************************************************

*.EQUATION
*.SCALE METER
*.MEGA
.PARAM

************************************************************************
* Library Name: tft3d_sc_t5
* Cell Name:    AND3_X1RL_T5
* View Name:    schematic
************************************************************************

.SUBCKT AND3_X1RL_T5 A1 A2 A3 VDD VSS Y
*.PININFO A1:I A2:I A3:I Y:O VDD:B VSS:B
RR3 VDD Y $[resmod] $W=600n $L=92.6u m=1 trise=0 ncorners=12 flg_local_she=-1
RR0 VDD net17 $[resmod] $W=600n $L=93.8u m=1 trise=0 ncorners=12
+ flg_local_she=-1
MM3 net09 A3 VSS nch W=1u L=600n m=1 trise=0 flg_local_she=-1
MM2 Y net17 VSS nch W=1u L=600n m=1 trise=0 flg_local_she=-1
MM0 net17 A1 M0_S_M1_D nch W=1u L=600n m=1 trise=0 flg_local_she=-1
MM1 M0_S_M1_D A2 net09 nch W=1u L=600n m=1 trise=0 flg_local_she=-1
.ENDS

************************************************************************
* auCdl Netlist:
*
* Library Name:  tft3d_sc_t5
* Top Cell Name: AND3_X2RL_T5
* View Name:     schematic
* Netlisted on:  Mar  3 13:34:21 2026
************************************************************************

*.EQUATION
*.SCALE METER
*.MEGA
.PARAM

************************************************************************
* Library Name: tft3d_sc_t5
* Cell Name:    AND3_X2RL_T5
* View Name:    schematic
************************************************************************

.SUBCKT AND3_X2RL_T5 A1 A2 A3 VDD VSS Y
*.PININFO A1:I A2:I A3:I Y:O VDD:B VSS:B
RR2 VDD YN $[resmod] $W=600n $L=93.8u m=1 trise=0 ncorners=12 flg_local_she=-1
RR1 VDD Y $[resmod] $W=600n $L=52.6u m=1 trise=0 ncorners=12 flg_local_she=-1
MM3 Y YN VSS nch W=1u L=600n m=1 trise=0 flg_local_she=-1
MM0 YN A1 net1 nch W=1u L=600n m=1 trise=0 flg_local_she=-1
MM1 net1 A2 net2 nch W=1u L=600n m=1 trise=0 flg_local_she=-1
MM2 net2 A3 VSS nch W=1u L=600n m=1 trise=0 flg_local_she=-1
.ENDS

************************************************************************
* auCdl Netlist:
*
* Library Name:  tft3d_sc_t5
* Top Cell Name: AND3_X4RL_T5
* View Name:     schematic
* Netlisted on:  Mar  3 13:34:22 2026
************************************************************************

*.EQUATION
*.SCALE METER
*.MEGA
.PARAM

************************************************************************
* Library Name: tft3d_sc_t5
* Cell Name:    AND3_X4RL_T5
* View Name:    schematic
************************************************************************

.SUBCKT AND3_X4RL_T5 A1 A2 A3 VDD VSS Y
*.PININFO A1:I A2:I A3:I Y:O VDD:B VSS:B
RR0 VDD YN $[resmod] $W=600n $L=93.8u m=1 trise=0 ncorners=12 flg_local_she=-1
RR1 VDD Y $[resmod] $W=600n $L=24.1u m=1 trise=0 ncorners=4 flg_local_she=-1
MM3 Y YN VSS nch W=1u L=600n m=1 trise=0 flg_local_she=-1
MM0 YN A1 net1 nch W=1u L=600n m=1 trise=0 flg_local_she=-1
MM1 net1 A2 net2 nch W=1u L=600n m=1 trise=0 flg_local_she=-1
MM2 net2 A3 VSS nch W=1u L=600n m=1 trise=0 flg_local_she=-1
.ENDS

************************************************************************
* auCdl Netlist:
*
* Library Name:  tft3d_sc_t5
* Top Cell Name: AND4_X1RL_T5
* View Name:     schematic
* Netlisted on:  Mar  3 13:34:19 2026
************************************************************************

*.EQUATION
*.SCALE METER
*.MEGA
.PARAM

************************************************************************
* Library Name: tft3d_sc_t5
* Cell Name:    AND4_X1RL_T5
* View Name:    schematic
************************************************************************

.SUBCKT AND4_X1RL_T5 A1 A2 A3 A4 VDD VSS Y
*.PININFO A1:I A2:I A3:I A4:I Y:O VDD:B VSS:B
RR3 VDD Y $[resmod] $W=600n $L=92.6u m=1 trise=0 ncorners=12 flg_local_she=-1
RR0 VDD net17 $[resmod] $W=600n $L=94.0u m=1 trise=0 ncorners=12
+ flg_local_she=-1
MM4 net010 A4 VSS nch W=1u L=600n m=1 trise=0 flg_local_she=-1
MM3 net09 A3 net010 nch W=1u L=600n m=1 trise=0 flg_local_she=-1
MM2 Y net17 VSS nch W=1u L=600n m=1 trise=0 flg_local_she=-1
MM0 net17 A1 M0_S_M1_D nch W=1u L=600n m=1 trise=0 flg_local_she=-1
MM1 M0_S_M1_D A2 net09 nch W=1u L=600n m=1 trise=0 flg_local_she=-1
.ENDS

************************************************************************
* auCdl Netlist:
*
* Library Name:  tft3d_sc_t5
* Top Cell Name: AND4_X2RL_T5
* View Name:     schematic
* Netlisted on:  Mar  3 13:34:49 2026
************************************************************************

*.EQUATION
*.SCALE METER
*.MEGA
.PARAM

************************************************************************
* Library Name: tft3d_sc_t5
* Cell Name:    AND4_X2RL_T5
* View Name:    schematic
************************************************************************

.SUBCKT AND4_X2RL_T5 A1 A2 A3 A4 VDD VSS Y
*.PININFO A1:I A2:I A3:I A4:I Y:O VDD:B VSS:B
RR1 VDD Y $[resmod] $W=600n $L=49.0u m=1 trise=0 ncorners=8 flg_local_she=-1
RR0 VDD YN $[resmod] $W=600n $L=94.0u m=1 trise=0 ncorners=13 flg_local_she=-1
MM4 Y YN VSS nch W=1u L=600n m=1 trise=0 flg_local_she=-1
MM0 YN A1 net1 nch W=1u L=600n m=1 trise=0 flg_local_she=-1
MM1 net1 A2 net2 nch W=1u L=600n m=1 trise=0 flg_local_she=-1
MM2 net2 A3 net3 nch W=1u L=600n m=1 trise=0 flg_local_she=-1
MM3 net3 A4 VSS nch W=1u L=600n m=1 trise=0 flg_local_she=-1
.ENDS

************************************************************************
* auCdl Netlist:
*
* Library Name:  tft3d_sc_t5
* Top Cell Name: AND4_X4RL_T5
* View Name:     schematic
* Netlisted on:  Mar  3 13:34:32 2026
************************************************************************

*.EQUATION
*.SCALE METER
*.MEGA
.PARAM

************************************************************************
* Library Name: tft3d_sc_t5
* Cell Name:    AND4_X4RL_T5
* View Name:    schematic
************************************************************************

.SUBCKT AND4_X4RL_T5 A1 A2 A3 A4 VDD VSS Y
*.PININFO A1:I A2:I A3:I A4:I Y:O VDD:B VSS:B
RR0 VDD YN $[resmod] $W=600n $L=94.0u m=1 trise=0 ncorners=13 flg_local_she=-1
RR1 VDD Y $[resmod] $W=600n $L=28.0u m=1 trise=0 ncorners=8 flg_local_she=-1
MM4 Y YN VSS nch W=1u L=600n m=1 trise=0 flg_local_she=-1
MM0 YN A1 net1 nch W=1u L=600n m=1 trise=0 flg_local_she=-1
MM1 net1 A2 net2 nch W=1u L=600n m=1 trise=0 flg_local_she=-1
MM2 net2 A3 net3 nch W=1u L=600n m=1 trise=0 flg_local_she=-1
MM3 net3 A4 VSS nch W=1u L=600n m=1 trise=0 flg_local_she=-1
.ENDS

************************************************************************
* auCdl Netlist:
*
* Library Name:  tft3d_sc_t5
* Top Cell Name: AOI211_X1RL_T5
* View Name:     schematic
* Netlisted on:  Mar  3 13:35:19 2026
************************************************************************

*.EQUATION
*.SCALE METER
*.MEGA
.PARAM

************************************************************************
* Library Name: tft3d_sc_t5
* Cell Name:    AOI211_X1RL_T5
* View Name:    schematic
************************************************************************

.SUBCKT AOI211_X1RL_T5 A1 A2 B C VDD VSS Y
*.PININFO A1:I A2:I B:I C:I Y:O VDD:B VSS:B
RR0 VDD Y $[resmod] $W=600n $L=92.7u m=1 trise=0 ncorners=12 flg_local_she=-1
MM3 Y C VSS nch W=1u L=600n m=1 trise=0 flg_local_she=-1
MM0 Y A1 M0_S_M1_D nch W=1u L=600n m=1 trise=0 flg_local_she=-1
MM1 M0_S_M1_D A2 VSS nch W=1u L=600n m=1 trise=0 flg_local_she=-1
MM2 Y B VSS nch W=1u L=600n m=1 trise=0 flg_local_she=-1
.ENDS

************************************************************************
* auCdl Netlist:
*
* Library Name:  tft3d_sc_t5
* Top Cell Name: AOI211_X2RL_T5
* View Name:     schematic
* Netlisted on:  Mar  3 13:34:37 2026
************************************************************************

*.EQUATION
*.SCALE METER
*.MEGA
.PARAM

************************************************************************
* Library Name: tft3d_sc_t5
* Cell Name:    AOI211_X2RL_T5
* View Name:    schematic
************************************************************************

.SUBCKT AOI211_X2RL_T5 A1 A2 B C VDD VSS Y
*.PININFO A1:I A2:I B:I C:I Y:O VDD:B VSS:B
RR0 VDD Y $[resmod] $W=600n $L=48.5u m=1 trise=0 ncorners=8 flg_local_she=-1
MM3 Y C VSS nch W=1u L=600n m=1 trise=0 flg_local_she=-1
MM0 Y A1 M0_S_M1_D nch W=1u L=600n m=1 trise=0 flg_local_she=-1
MM1 M0_S_M1_D A2 VSS nch W=1u L=600n m=1 trise=0 flg_local_she=-1
MM2 Y B VSS nch W=1u L=600n m=1 trise=0 flg_local_she=-1
.ENDS

************************************************************************
* auCdl Netlist:
*
* Library Name:  tft3d_sc_t5
* Top Cell Name: AOI211_X4RL_T5
* View Name:     schematic
* Netlisted on:  Mar  3 13:34:37 2026
************************************************************************

*.EQUATION
*.SCALE METER
*.MEGA
.PARAM

************************************************************************
* Library Name: tft3d_sc_t5
* Cell Name:    AOI211_X4RL_T5
* View Name:    schematic
************************************************************************

.SUBCKT AOI211_X4RL_T5 A1 A2 B C VDD VSS Y
*.PININFO A1:I A2:I B:I C:I Y:O VDD:B VSS:B
RR0 VDD Y $[resmod] $W=600n $L=24.1u m=1 trise=0 ncorners=4 flg_local_she=-1
MM3 Y C VSS nch W=1u L=600n m=1 trise=0 flg_local_she=-1
MM0 Y A1 M0_S_M1_D nch W=1u L=600n m=1 trise=0 flg_local_she=-1
MM1 M0_S_M1_D A2 VSS nch W=1u L=600n m=1 trise=0 flg_local_she=-1
MM2 Y B VSS nch W=1u L=600n m=1 trise=0 flg_local_she=-1
.ENDS

************************************************************************
* auCdl Netlist:
*
* Library Name:  tft3d_sc_t5
* Top Cell Name: AOI21_X1RL_T5
* View Name:     schematic
* Netlisted on:  Mar  3 13:34:20 2026
************************************************************************

*.EQUATION
*.SCALE METER
*.MEGA
.PARAM

************************************************************************
* Library Name: tft3d_sc_t5
* Cell Name:    AOI21_X1RL_T5
* View Name:    schematic
************************************************************************

.SUBCKT AOI21_X1RL_T5 A1 A2 B VDD VSS Y
*.PININFO A1:I A2:I B:I Y:O VDD:B VSS:B
RR0 VDD Y $[resmod] $W=600n $L=92.7u m=1 trise=0 ncorners=12 flg_local_she=-1
MM2 Y B VSS nch W=1u L=600n m=1 trise=0 flg_local_she=-1
MM0 Y A1 M0_S_M1_D nch W=1u L=600n m=1 trise=0 flg_local_she=-1
MM1 M0_S_M1_D A2 VSS nch W=1u L=600n m=1 trise=0 flg_local_she=-1
.ENDS

************************************************************************
* auCdl Netlist:
*
* Library Name:  tft3d_sc_t5
* Top Cell Name: AOI21_X2RL_T5
* View Name:     schematic
* Netlisted on:  Mar  3 13:34:31 2026
************************************************************************

*.EQUATION
*.SCALE METER
*.MEGA
.PARAM

************************************************************************
* Library Name: tft3d_sc_t5
* Cell Name:    AOI21_X2RL_T5
* View Name:    schematic
************************************************************************

.SUBCKT AOI21_X2RL_T5 A1 A2 B VDD VSS Y
*.PININFO A1:I A2:I B:I Y:O VDD:B VSS:B
RR0 VDD Y $[resmod] $W=600n $L=52.1u m=1 trise=0 ncorners=12 flg_local_she=-1
MM2 Y B VSS nch W=1u L=600n m=1 trise=0 flg_local_she=-1
MM0 Y A1 M0_S_M1_D nch W=1u L=600n m=1 trise=0 flg_local_she=-1
MM1 M0_S_M1_D A2 VSS nch W=1u L=600n m=1 trise=0 flg_local_she=-1
.ENDS

************************************************************************
* auCdl Netlist:
*
* Library Name:  tft3d_sc_t5
* Top Cell Name: AOI21_X4RL_T5
* View Name:     schematic
* Netlisted on:  Mar  3 13:34:31 2026
************************************************************************

*.EQUATION
*.SCALE METER
*.MEGA
.PARAM

************************************************************************
* Library Name: tft3d_sc_t5
* Cell Name:    AOI21_X4RL_T5
* View Name:    schematic
************************************************************************

.SUBCKT AOI21_X4RL_T5 A1 A2 B VDD VSS Y
*.PININFO A1:I A2:I B:I Y:O VDD:B VSS:B
RR0 VDD Y $[resmod] $W=600n $L=28.0u m=1 trise=0 ncorners=8 flg_local_she=-1
MM2 Y B VSS nch W=1u L=600n m=1 trise=0 flg_local_she=-1
MM0 Y A1 M0_S_M1_D nch W=1u L=600n m=1 trise=0 flg_local_she=-1
MM1 M0_S_M1_D A2 VSS nch W=1u L=600n m=1 trise=0 flg_local_she=-1
.ENDS

************************************************************************
* auCdl Netlist:
*
* Library Name:  tft3d_sc_t5
* Top Cell Name: AOI22_X1RL_T5
* View Name:     schematic
* Netlisted on:  Mar  3 13:34:21 2026
************************************************************************

*.EQUATION
*.SCALE METER
*.MEGA
.PARAM

************************************************************************
* Library Name: tft3d_sc_t5
* Cell Name:    AOI22_X1RL_T5
* View Name:    schematic
************************************************************************

.SUBCKT AOI22_X1RL_T5 A1 A2 B1 B2 VDD VSS Y
*.PININFO A1:I A2:I B1:I B2:I Y:O VDD:B VSS:B
RR0 VDD Y $[resmod] $W=600n $L=92.7u m=1 trise=0 ncorners=12 flg_local_she=-1
MM3 net20 B2 VSS nch W=1u L=600n m=1 trise=0 flg_local_she=-1
MM0 Y A1 M0_S_M1_D nch W=1u L=600n m=1 trise=0 flg_local_she=-1
MM1 M0_S_M1_D A2 VSS nch W=1u L=600n m=1 trise=0 flg_local_she=-1
MM2 Y B1 net20 nch W=1u L=600n m=1 trise=0 flg_local_she=-1
.ENDS

************************************************************************
* auCdl Netlist:
*
* Library Name:  tft3d_sc_t5
* Top Cell Name: AOI22_X2RL_T5
* View Name:     schematic
* Netlisted on:  Mar  3 13:34:22 2026
************************************************************************

*.EQUATION
*.SCALE METER
*.MEGA
.PARAM

************************************************************************
* Library Name: tft3d_sc_t5
* Cell Name:    AOI22_X2RL_T5
* View Name:    schematic
************************************************************************

.SUBCKT AOI22_X2RL_T5 A1 A2 B1 B2 VDD VSS Y
*.PININFO A1:I A2:I B1:I B2:I Y:O VDD:B VSS:B
RR0 VDD Y $[resmod] $W=600n $L=48.5u m=1 trise=0 ncorners=8 flg_local_she=-1
MM3 net20 B2 VSS nch W=1u L=600n m=1 trise=0 flg_local_she=-1
MM0 Y A1 M0_S_M1_D nch W=1u L=600n m=1 trise=0 flg_local_she=-1
MM1 M0_S_M1_D A2 VSS nch W=1u L=600n m=1 trise=0 flg_local_she=-1
MM2 Y B1 net20 nch W=1u L=600n m=1 trise=0 flg_local_she=-1
.ENDS

************************************************************************
* auCdl Netlist:
*
* Library Name:  tft3d_sc_t5
* Top Cell Name: AOI22_X4RL_T5
* View Name:     schematic
* Netlisted on:  Mar  3 13:34:43 2026
************************************************************************

*.EQUATION
*.SCALE METER
*.MEGA
.PARAM

************************************************************************
* Library Name: tft3d_sc_t5
* Cell Name:    AOI22_X4RL_T5
* View Name:    schematic
************************************************************************

.SUBCKT AOI22_X4RL_T5 A1 A2 B1 B2 VDD VSS Y
*.PININFO A1:I A2:I B1:I B2:I Y:O VDD:B VSS:B
RR0 VDD Y $[resmod] $W=600n $L=24.1u m=1 trise=0 ncorners=4 flg_local_she=-1
MM3 net20 B2 VSS nch W=2u L=600n m=1 trise=0 flg_local_she=-1
MM0 Y A1 M0_S_M1_D nch W=2u L=600n m=1 trise=0 flg_local_she=-1
MM1 M0_S_M1_D A2 VSS nch W=2u L=600n m=1 trise=0 flg_local_she=-1
MM2 Y B1 net20 nch W=2u L=600n m=1 trise=0 flg_local_she=-1
.ENDS

************************************************************************
* auCdl Netlist:
*
* Library Name:  tft3d_sc_t5
* Top Cell Name: BUF_X1PC_T5
* View Name:     schematic
* Netlisted on:  Mar  3 13:34:31 2026
************************************************************************

*.EQUATION
*.SCALE METER
*.MEGA
.PARAM

************************************************************************
* Library Name: tft3d_sc_t5
* Cell Name:    BUF_X1PC_T5
* View Name:    schematic
************************************************************************

.SUBCKT BUF_X1PC_T5 A VDD VSS Y
*.PININFO A:I Y:O VDD:B VSS:B
RR1 VDD ANN $[resmod] $W=600n $L=90.6u m=1 trise=0 ncorners=10 flg_local_she=-1
RR0 VDD AN $[resmod] $W=600n $L=92.7u m=1 trise=0 ncorners=12 flg_local_she=-1
MM3 Y AN VSS nch W=1u L=600n m=1 trise=0 flg_local_she=-1
MM2 VDD ANN Y nch W=1u L=600n m=1 trise=0 flg_local_she=-1
MM1 ANN AN VSS nch W=1u L=600n m=1 trise=0 flg_local_she=-1
MM0 AN A VSS nch W=1u L=600n m=1 trise=0 flg_local_she=-1
.ENDS

************************************************************************
* auCdl Netlist:
*
* Library Name:  tft3d_sc_t5
* Top Cell Name: BUF_X1RL_T5
* View Name:     schematic
* Netlisted on:  Mar  3 13:34:22 2026
************************************************************************

*.EQUATION
*.SCALE METER
*.MEGA
.PARAM

************************************************************************
* Library Name: tft3d_sc_t5
* Cell Name:    BUF_X1RL_T5
* View Name:    schematic
************************************************************************

.SUBCKT BUF_X1RL_T5 A VDD VSS Y
*.PININFO A:I Y:O VDD:B VSS:B
RR1 VDD Y $[resmod] $W=600n $L=96.4u m=1 trise=0 ncorners=16 flg_local_she=-1
RR0 VDD ABAR $[resmod] $W=600n $L=98.6u m=1 trise=0 ncorners=18
+ flg_local_she=-1
MM1 Y ABAR VSS nch W=1u L=600n m=1 trise=0 flg_local_she=-1
MM0 ABAR A VSS nch W=1u L=600n m=1 trise=0 flg_local_she=-1
.ENDS

************************************************************************
* auCdl Netlist:
*
* Library Name:  tft3d_sc_t5
* Top Cell Name: BUF_X2PC_T5
* View Name:     schematic
* Netlisted on:  Mar  3 13:34:22 2026
************************************************************************

*.EQUATION
*.SCALE METER
*.MEGA
.PARAM

************************************************************************
* Library Name: tft3d_sc_t5
* Cell Name:    BUF_X2PC_T5
* View Name:    schematic
************************************************************************

.SUBCKT BUF_X2PC_T5 A VDD VSS Y
*.PININFO A:I Y:O VDD:B VSS:B
RR1 VDD ANN $[resmod] $W=600n $L=48.2u m=1 trise=0 ncorners=8 flg_local_she=-1
RR0 VDD AN $[resmod] $W=600n $L=92.7u m=1 trise=0 ncorners=12 flg_local_she=-1
MM3 Y AN VSS nch W=2u L=600n m=1 trise=0 flg_local_she=-1
MM2 VDD ANN Y nch W=2u L=600n m=1 trise=0 flg_local_she=-1
MM1 ANN AN VSS nch W=2u L=600n m=1 trise=0 flg_local_she=-1
MM0 AN A VSS nch W=1u L=600n m=1 trise=0 flg_local_she=-1
.ENDS

************************************************************************
* auCdl Netlist:
*
* Library Name:  tft3d_sc_t5
* Top Cell Name: BUF_X2RL_T5
* View Name:     schematic
* Netlisted on:  Mar  3 13:34:31 2026
************************************************************************

*.EQUATION
*.SCALE METER
*.MEGA
.PARAM

************************************************************************
* Library Name: tft3d_sc_t5
* Cell Name:    BUF_X2RL_T5
* View Name:    schematic
************************************************************************

.SUBCKT BUF_X2RL_T5 A VDD VSS Y
*.PININFO A:I Y:O VDD:B VSS:B
RR1 VDD Y $[resmod] $W=600n $L=50.6u m=1 trise=0 ncorners=12 flg_local_she=-1
RR0 VDD AN $[resmod] $W=600n $L=98.6u m=1 trise=0 ncorners=18 flg_local_she=-1
MM0 AN A VSS nch W=1u L=600n m=1 trise=0 flg_local_she=-1
MM1 Y AN VSS nch W=1u L=600n m=1 trise=0 flg_local_she=-1
.ENDS

************************************************************************
* auCdl Netlist:
*
* Library Name:  tft3d_sc_t5
* Top Cell Name: BUF_X4PC_T5
* View Name:     schematic
* Netlisted on:  Mar  3 13:34:23 2026
************************************************************************

*.EQUATION
*.SCALE METER
*.MEGA
.PARAM

************************************************************************
* Library Name: tft3d_sc_t5
* Cell Name:    BUF_X4PC_T5
* View Name:    schematic
************************************************************************

.SUBCKT BUF_X4PC_T5 A VDD VSS Y
*.PININFO A:I Y:O VDD:B VSS:B
RR1 VDD ANN $[resmod] $W=600n $L=28.0u m=1 trise=0 ncorners=6 flg_local_she=-1
RR0 VDD AN $[resmod] $W=600n $L=91.3u m=1 trise=0 ncorners=12 flg_local_she=-1
MM3 Y AN VSS nch W=4u L=600n m=1 trise=0 flg_local_she=-1
MM2 VDD ANN Y nch W=4u L=600n m=1 trise=0 flg_local_she=-1
MM1 ANN AN VSS nch W=4u L=600n m=1 trise=0 flg_local_she=-1
MM0 AN A VSS nch W=1u L=600n m=1 trise=0 flg_local_she=-1
.ENDS

************************************************************************
* auCdl Netlist:
*
* Library Name:  tft3d_sc_t5
* Top Cell Name: BUF_X4RL_T5
* View Name:     schematic
* Netlisted on:  Mar  3 13:34:23 2026
************************************************************************

*.EQUATION
*.SCALE METER
*.MEGA
.PARAM

************************************************************************
* Library Name: tft3d_sc_t5
* Cell Name:    BUF_X4RL_T5
* View Name:    schematic
************************************************************************

.SUBCKT BUF_X4RL_T5 A VDD VSS Y
*.PININFO A:I Y:O VDD:B VSS:B
RR1 VDD Y $[resmod] $W=600n $L=29.8u m=1 trise=0 ncorners=12 flg_local_she=-1
RR0 VDD ABAR $[resmod] $W=600n $L=98.6u m=1 trise=0 ncorners=18
+ flg_local_she=-1
MM1 Y ABAR VSS nch W=2u L=600n m=1 trise=0 flg_local_she=-1
MM0 ABAR A VSS nch W=1u L=600n m=1 trise=0 flg_local_she=-1
.ENDS

************************************************************************
* auCdl Netlist:
*
* Library Name:  tft3d_sc_t5
* Top Cell Name: CLKBUF_F2X2PC_T5
* View Name:     schematic
* Netlisted on:  Mar  3 13:34:23 2026
************************************************************************

*.EQUATION
*.SCALE METER
*.MEGA
.PARAM

************************************************************************
* Library Name: tft3d_sc_t5
* Cell Name:    CLKBUF_F2X2PC_T5
* View Name:    schematic
************************************************************************

.SUBCKT CLKBUF_F2X2PC_T5 Y VDD VSS A
*.PININFO A:I Y:O VDD:B VSS:B
RR1 VDD ANN $[resmod] $W=600n $L=13.0u m=1 trise=0 ncorners=4 flg_local_she=-1
RR0 VDD AN $[resmod] $W=600n $L=13.0u m=1 trise=0 ncorners=4 flg_local_she=-1
MM3 Y AN VSS nch W=2u L=600n m=1 trise=0 flg_local_she=-1
MM2 VDD ANN Y nch W=2u L=600n m=1 trise=0 flg_local_she=-1
MM1 ANN AN VSS nch W=1u L=600n m=1 trise=0 flg_local_she=-1
MM0 AN A VSS nch W=4u L=600n m=1 trise=0 flg_local_she=-1
.ENDS

************************************************************************
* auCdl Netlist:
*
* Library Name:  tft3d_sc_t5
* Top Cell Name: CLKBUF_F4X2PC_T5
* View Name:     schematic
* Netlisted on:  Mar  3 13:34:23 2026
************************************************************************

*.EQUATION
*.SCALE METER
*.MEGA
.PARAM

************************************************************************
* Library Name: tft3d_sc_t5
* Cell Name:    CLKBUF_F4X2PC_T5
* View Name:    schematic
************************************************************************

.SUBCKT CLKBUF_F4X2PC_T5 Y VDD VSS A
*.PININFO A:I Y:O VDD:B VSS:B
RR1 VDD ANN $[resmod] $W=600n $L=3u m=1 trise=0 ncorners=0 flg_local_she=-1
RR2 VDD AN $[resmod] $W=600n $L=4.3u m=1 trise=0 ncorners=0 flg_local_she=-1
MM3 Y AN VSS nch W=2u L=600n m=1 trise=0 flg_local_she=-1
MM2 VDD ANN Y nch W=4u L=600n m=1 trise=0 flg_local_she=-1
MM1 ANN AN VSS nch W=1u L=600n m=1 trise=0 flg_local_she=-1
MM0 AN A VSS nch W=4u L=600n m=1 trise=0 flg_local_she=-1
.ENDS

************************************************************************
* auCdl Netlist:
*
* Library Name:  tft3d_sc_t5
* Top Cell Name: CLKBUF_X2PC_T5
* View Name:     schematic
* Netlisted on:  Mar  3 13:34:23 2026
************************************************************************

*.EQUATION
*.SCALE METER
*.MEGA
.PARAM

************************************************************************
* Library Name: tft3d_sc_t5
* Cell Name:    CLKBUF_X2PC_T5
* View Name:    schematic
************************************************************************

.SUBCKT CLKBUF_X2PC_T5 Y VDD VSS A
*.PININFO A:I Y:O VDD:B VSS:B
RR1 VDD ANN $[resmod] $W=600n $L=23.0u m=1 trise=0 ncorners=8 flg_local_she=-1
RR0 VDD AN $[resmod] $W=600n $L=23.0u m=1 trise=0 ncorners=8 flg_local_she=-1
MM3 Y AN VSS nch W=2u L=600n m=1 trise=0 flg_local_she=-1
MM2 VDD ANN Y nch W=2u L=600n m=1 trise=0 flg_local_she=-1
MM1 ANN AN VSS nch W=1u L=600n m=1 trise=0 flg_local_she=-1
MM0 AN A VSS nch W=1u L=600n m=1 trise=0 flg_local_she=-1
.ENDS

************************************************************************
* auCdl Netlist:
*
* Library Name:  tft3d_sc_t5
* Top Cell Name: CLKBUF_X8PC_T5
* View Name:     schematic
* Netlisted on:  Mar  3 13:34:32 2026
************************************************************************

*.EQUATION
*.SCALE METER
*.MEGA
.PARAM

************************************************************************
* Library Name: tft3d_sc_t5
* Cell Name:    CLKBUF_X8PC_T5
* View Name:    schematic
************************************************************************

.SUBCKT CLKBUF_X8PC_T5 Y VDD VSS A
*.PININFO A:I Y:O VDD:B VSS:B
RR3 VDD AN $[resmod] $W=600n $L=26.2u m=1 trise=0 ncorners=12 flg_local_she=-1
RR1 VDD ANN $[resmod] $W=600n $L=14.2u m=1 trise=0 ncorners=4 flg_local_she=-1
MM3 Y AN VSS nch W=8u L=600n m=1 trise=0 flg_local_she=-1
MM2 VDD ANN Y nch W=8u L=600n m=1 trise=0 flg_local_she=-1
MM1 ANN AN VSS nch W=2u L=600n m=1 trise=0 flg_local_she=-1
MM0 AN A VSS nch W=2u L=600n m=1 trise=0 flg_local_she=-1
.ENDS

************************************************************************
* auCdl Netlist:
*
* Library Name:  tft3d_sc_t5
* Top Cell Name: DFFC_F2X1PC_T5
* View Name:     schematic
* Netlisted on:  Mar  3 13:34:24 2026
************************************************************************

*.EQUATION
*.SCALE METER
*.MEGA
.PARAM

************************************************************************
* Library Name: tft3d_sc_t5
* Cell Name:    DFFC_F2X1PC_T5
* View Name:    schematic
************************************************************************

.SUBCKT DFFC_F2X1PC_T5 Q QN VDD VSS CLK CLR D
*.PININFO CLK:I CLR:I D:I Q:O QN:O VDD:B VSS:B
RR2 VDD MN $[resmod] $W=600n $L=92.2u m=1 trise=0 ncorners=16 flg_local_she=-1
RR3 VDD M $[resmod] $W=600n $L=98.6u m=1 trise=0 ncorners=18 flg_local_she=-1
RR4 VDD SN $[resmod] $W=600n $L=50.6u m=1 trise=0 ncorners=8 flg_local_she=-1
RR5 VDD S $[resmod] $W=600n $L=50.6u m=1 trise=0 ncorners=10 flg_local_she=-1
RR0 VDD CLKN $[resmod] $W=600n $L=24.1u m=1 trise=0 ncorners=4 flg_local_she=-1
RR1 VDD CLKNN $[resmod] $W=600n $L=24.1u m=1 trise=0 ncorners=4
+ flg_local_she=-1
MM2 D CLKN D_ nch W=1u L=600n m=1 trise=0 flg_local_she=-1
MM3 D_ CLKNN M nch W=1u L=600n m=1 trise=0 flg_local_she=-1
MM4 MN D_ VSS nch W=1u L=600n m=1 trise=0 flg_local_she=-1
MM5 M MN VSS nch W=1u L=600n m=1 trise=0 flg_local_she=-1
MM6 MN CLKNN MN_ nch W=1u L=600n m=1 trise=0 flg_local_she=-1
MM7 MN_ CLKN S nch W=1u L=600n m=1 trise=0 flg_local_she=-1
MM8 SN MN_ VSS nch W=1u L=600n m=1 trise=0 flg_local_she=-1
MM9 S SN VSS nch W=1u L=600n m=1 trise=0 flg_local_she=-1
MM0 CLKN CLK VSS nch W=1u L=600n m=1 trise=0 flg_local_she=-1
MM1 CLKNN CLKN VSS nch W=1u L=600n m=1 trise=0 flg_local_she=-1
MM10 QN SN VSS nch W=1u L=600n m=1 trise=0 flg_local_she=-1
MM11 Q S VSS nch W=1u L=600n m=1 trise=0 flg_local_she=-1
MM12 VDD S QN nch W=1u L=600n m=1 trise=0 flg_local_she=-1
MM13 VDD SN Q nch W=1u L=600n m=1 trise=0 flg_local_she=-1
MM14 M CLR VSS nch W=1u L=600n m=1 trise=0 flg_local_she=-1
MM15 SN CLR VSS nch W=1u L=600n m=1 trise=0 flg_local_she=-1
.ENDS

************************************************************************
* auCdl Netlist:
*
* Library Name:  tft3d_sc_t5
* Top Cell Name: DFFC_F4X1PC_T5
* View Name:     schematic
* Netlisted on:  Mar  3 13:34:24 2026
************************************************************************

*.EQUATION
*.SCALE METER
*.MEGA
.PARAM

************************************************************************
* Library Name: tft3d_sc_t5
* Cell Name:    DFFC_F4X1PC_T5
* View Name:    schematic
************************************************************************

.SUBCKT DFFC_F4X1PC_T5 Q QN VDD VSS CLK CLR D
*.PININFO CLK:I CLR:I D:I Q:O QN:O VDD:B VSS:B
RR7 VDD M $[resmod] $W=600n $L=48.5u m=1 trise=0 ncorners=8 flg_local_she=-1
RR6 VDD MN $[resmod] $W=600n $L=48.2u m=1 trise=0 ncorners=8 flg_local_she=-1
RR8 VDD CLKN $[resmod] $W=600n $L=10.1u m=1 trise=0 ncorners=0 flg_local_she=-1
RR9 VDD CLKNN $[resmod] $W=600n $L=10.1u m=1 trise=0 ncorners=0
+ flg_local_she=-1
RR5 VDD S $[resmod] $W=600n $L=24.1u m=1 trise=0 ncorners=4 flg_local_she=-1
RR4 VDD SN $[resmod] $W=600n $L=24.1u m=1 trise=0 ncorners=4 flg_local_she=-1
MM15 SN CLR VSS nch W=1u L=600n m=1 trise=0 flg_local_she=-1
MM14 M CLR VSS nch W=1u L=600n m=1 trise=0 flg_local_she=-1
MM13 VDD SN Q nch W=1u L=600n m=1 trise=0 flg_local_she=-1
MM12 VDD S QN nch W=1u L=600n m=1 trise=0 flg_local_she=-1
MM11 Q S VSS nch W=1u L=600n m=1 trise=0 flg_local_she=-1
MM10 QN SN VSS nch W=1u L=600n m=1 trise=0 flg_local_she=-1
MM1 CLKNN CLKN VSS nch W=1u L=600n m=1 trise=0 flg_local_she=-1
MM0 CLKN CLK VSS nch W=1u L=600n m=1 trise=0 flg_local_she=-1
MM9 S SN VSS nch W=1u L=600n m=1 trise=0 flg_local_she=-1
MM8 SN MN_ VSS nch W=1u L=600n m=1 trise=0 flg_local_she=-1
MM7 MN_ CLKN S nch W=1u L=600n m=1 trise=0 flg_local_she=-1
MM6 MN CLKNN MN_ nch W=1u L=600n m=1 trise=0 flg_local_she=-1
MM5 M MN VSS nch W=1u L=600n m=1 trise=0 flg_local_she=-1
MM4 MN D_ VSS nch W=1u L=600n m=1 trise=0 flg_local_she=-1
MM3 D_ CLKNN M nch W=1u L=600n m=1 trise=0 flg_local_she=-1
MM2 D CLKN D_ nch W=1u L=600n m=1 trise=0 flg_local_she=-1
.ENDS

************************************************************************
* auCdl Netlist:
*
* Library Name:  tft3d_sc_t5
* Top Cell Name: DFFC_X1PC_T5
* View Name:     schematic
* Netlisted on:  Mar  3 13:35:19 2026
************************************************************************

*.EQUATION
*.SCALE METER
*.MEGA
.PARAM

************************************************************************
* Library Name: tft3d_sc_t5
* Cell Name:    DFFC_X1PC_T5
* View Name:    schematic
************************************************************************

.SUBCKT DFFC_X1PC_T5 Q QN VDD VSS CLK CLR D
*.PININFO CLK:I CLR:I D:I Q:O QN:O VDD:B VSS:B
RR1 VDD CLKNN $[resmod] $W=600n $L=96.4u m=1 trise=0 ncorners=16
+ flg_local_she=-1
RR0 VDD CLKN $[resmod] $W=600n $L=90.6u m=1 trise=0 ncorners=10
+ flg_local_she=-1
RR5 VDD S $[resmod] $W=600n $L=92.8u m=1 trise=0 ncorners=10 flg_local_she=-1
RR4 VDD SN $[resmod] $W=600n $L=98.6u m=1 trise=0 ncorners=18 flg_local_she=-1
RR3 VDD M $[resmod] $W=600n $L=98.6u m=1 trise=0 ncorners=18 flg_local_she=-1
RR2 VDD MN $[resmod] $W=600n $L=92.6u m=1 trise=0 ncorners=12 flg_local_she=-1
MM15 SN CLR VSS nch W=1u L=600n m=1 trise=0 flg_local_she=-1
MM14 M CLR VSS nch W=1u L=600n m=1 trise=0 flg_local_she=-1
MM13 VDD SN Q nch W=1u L=600n m=1 trise=0 flg_local_she=-1
MM12 VDD S QN nch W=1u L=600n m=1 trise=0 flg_local_she=-1
MM11 Q S VSS nch W=1u L=600n m=1 trise=0 flg_local_she=-1
MM10 QN SN VSS nch W=1u L=600n m=1 trise=0 flg_local_she=-1
MM1 CLKNN CLKN VSS nch W=1u L=600n m=1 trise=0 flg_local_she=-1
MM0 CLKN CLK VSS nch W=1u L=600n m=1 trise=0 flg_local_she=-1
MM9 S SN VSS nch W=1u L=600n m=1 trise=0 flg_local_she=-1
MM8 SN MN_ VSS nch W=1u L=600n m=1 trise=0 flg_local_she=-1
MM7 MN_ CLKN S nch W=1u L=600n m=1 trise=0 flg_local_she=-1
MM6 MN CLKNN MN_ nch W=1u L=600n m=1 trise=0 flg_local_she=-1
MM5 M MN VSS nch W=1u L=600n m=1 trise=0 flg_local_she=-1
MM4 MN D_ VSS nch W=1u L=600n m=1 trise=0 flg_local_she=-1
MM3 D_ CLKNN M nch W=1u L=600n m=1 trise=0 flg_local_she=-1
MM2 D CLKN D_ nch W=1u L=600n m=1 trise=0 flg_local_she=-1
.ENDS

************************************************************************
* auCdl Netlist:
*
* Library Name:  tft3d_sc_t5
* Top Cell Name: DFF_X1PC_T5
* View Name:     schematic
* Netlisted on:  Mar  3 13:34:31 2026
************************************************************************

*.EQUATION
*.SCALE METER
*.MEGA
.PARAM

************************************************************************
* Library Name: tft3d_sc_t5
* Cell Name:    DFF_X1PC_T5
* View Name:    schematic
************************************************************************

.SUBCKT DFF_X1PC_T5 Q QN VDD VSS CLK D
*.PININFO CLK:I D:I Q:O QN:O VDD:B VSS:B
RR1 VDD CLKNN $[resmod] $W=600n $L=96.4u m=1 trise=0 ncorners=16
+ flg_local_she=-1
RR0 VDD CLKN $[resmod] $W=600n $L=90.6u m=1 trise=0 ncorners=10
+ flg_local_she=-1
RR5 VDD S $[resmod] $W=600n $L=92.8u m=1 trise=0 ncorners=10 flg_local_she=-1
RR4 VDD SN $[resmod] $W=600n $L=98.6u m=1 trise=0 ncorners=18 flg_local_she=-1
RR3 VDD M $[resmod] $W=600n $L=98.6u m=1 trise=0 ncorners=18 flg_local_she=-1
RR2 VDD MN $[resmod] $W=600n $L=92.6u m=1 trise=0 ncorners=12 flg_local_she=-1
MM13 VDD SN Q nch W=1u L=600n m=1 trise=0 flg_local_she=-1
MM12 VDD S QN nch W=1u L=600n m=1 trise=0 flg_local_she=-1
MM11 Q S VSS nch W=1u L=600n m=1 trise=0 flg_local_she=-1
MM10 QN SN VSS nch W=1u L=600n m=1 trise=0 flg_local_she=-1
MM1 CLKNN CLKN VSS nch W=1u L=600n m=1 trise=0 flg_local_she=-1
MM0 CLKN CLK VSS nch W=1u L=600n m=1 trise=0 flg_local_she=-1
MM9 S SN VSS nch W=1u L=600n m=1 trise=0 flg_local_she=-1
MM8 SN MN_ VSS nch W=1u L=600n m=1 trise=0 flg_local_she=-1
MM7 MN_ CLKN S nch W=1u L=600n m=1 trise=0 flg_local_she=-1
MM6 MN CLKNN MN_ nch W=1u L=600n m=1 trise=0 flg_local_she=-1
MM5 M MN VSS nch W=1u L=600n m=1 trise=0 flg_local_she=-1
MM4 MN D_ VSS nch W=1u L=600n m=1 trise=0 flg_local_she=-1
MM3 D_ CLKNN M nch W=1u L=600n m=1 trise=0 flg_local_she=-1
MM2 D CLKN D_ nch W=1u L=600n m=1 trise=0 flg_local_she=-1
.ENDS

************************************************************************
* auCdl Netlist:
*
* Library Name:  tft3d_sc_t5
* Top Cell Name: DLY1_X1PC_T5
* View Name:     schematic
* Netlisted on:  Mar  3 13:34:25 2026
************************************************************************

*.EQUATION
*.SCALE METER
*.MEGA
.PARAM

************************************************************************
* Library Name: tft3d_sc_t5
* Cell Name:    DLY1_X1PC_T5
* View Name:    schematic
************************************************************************

.SUBCKT DLY1_X1PC_T5 Y VDD VSS A
*.PININFO A:I Y:O VDD:B VSS:B
RR1 VDD ANN $[resmod] $W=600n $L=92.7u m=1 trise=0 ncorners=12 flg_local_she=-1
RR0 VDD AN $[resmod] $W=600n $L=91.4u m=1 trise=0 ncorners=10 flg_local_she=-1
CC0 AN VSS capmod trise=0 area=1.2e-11 perim=1.6e-05 m=1
MM3 Y AN VSS nch W=1u L=1.2u m=1 trise=0 flg_local_she=-1
MM2 VDD ANN Y nch W=1u L=1.2u m=1 trise=0 flg_local_she=-1
MM1 ANN AN VSS nch W=1u L=600n m=1 trise=0 flg_local_she=-1
MM0 AN A VSS nch W=1u L=1.2u m=1 trise=0 flg_local_she=-1
.ENDS

************************************************************************
* auCdl Netlist:
*
* Library Name:  tft3d_sc_t5
* Top Cell Name: DLY1_X1RL_T5
* View Name:     schematic
* Netlisted on:  Mar  3 13:34:25 2026
************************************************************************

*.EQUATION
*.SCALE METER
*.MEGA
.PARAM

************************************************************************
* Library Name: tft3d_sc_t5
* Cell Name:    DLY1_X1RL_T5
* View Name:    schematic
************************************************************************

.SUBCKT DLY1_X1RL_T5 Y VDD VSS A
*.PININFO A:I Y:O VDD:B VSS:B
RR0 VDD AN $[resmod] $W=600n $L=29.8u m=1 trise=0 ncorners=12 flg_local_she=-1
RR1 VDD Y $[resmod] $W=600n $L=92.7u m=1 trise=0 ncorners=12 flg_local_she=-1
CC0 AN VSS capmod trise=0 area=1.2e-11 perim=1.6e-05 m=1
MM0 AN A VSS nch W=1u L=600n m=1 trise=0 flg_local_she=-1
MM1 Y AN VSS nch W=1u L=600n m=1 trise=0 flg_local_she=-1
.ENDS

************************************************************************
* auCdl Netlist:
*
* Library Name:  tft3d_sc_t5
* Top Cell Name: DLY2_X1PC_T5
* View Name:     schematic
* Netlisted on:  Mar  3 13:34:25 2026
************************************************************************

*.EQUATION
*.SCALE METER
*.MEGA
.PARAM

************************************************************************
* Library Name: tft3d_sc_t5
* Cell Name:    DLY2_X1PC_T5
* View Name:    schematic
************************************************************************

.SUBCKT DLY2_X1PC_T5 Y VDD VSS A
*.PININFO A:I Y:O VDD:B VSS:B
RR0 VDD AN $[resmod] $W=600n $L=91.4u m=1 trise=0 ncorners=10 flg_local_she=-1
RR1 VDD ANN $[resmod] $W=600n $L=92.6u m=1 trise=0 ncorners=12 flg_local_she=-1
CC0 AN VSS capmod trise=0 area=2.4e-11 perim=2e-05 m=1
MM0 AN A VSS nch W=1u L=1.2u m=1 trise=0 flg_local_she=-1
MM1 ANN AN VSS nch W=1u L=600n m=1 trise=0 flg_local_she=-1
MM2 VDD ANN Y nch W=1u L=1.2u m=1 trise=0 flg_local_she=-1
MM3 Y AN VSS nch W=1u L=1.2u m=1 trise=0 flg_local_she=-1
.ENDS

************************************************************************
* auCdl Netlist:
*
* Library Name:  tft3d_sc_t5
* Top Cell Name: DLY2_X1RL_T5
* View Name:     schematic
* Netlisted on:  Mar  3 13:34:28 2026
************************************************************************

*.EQUATION
*.SCALE METER
*.MEGA
.PARAM

************************************************************************
* Library Name: tft3d_sc_t5
* Cell Name:    DLY2_X1RL_T5
* View Name:    schematic
************************************************************************

.SUBCKT DLY2_X1RL_T5 Y VDD VSS A
*.PININFO A:I Y:O VDD:B VSS:B
RR0 VDD AN $[resmod] $W=600n $L=29.8u m=1 trise=0 ncorners=4 flg_local_she=-1
RR1 VDD Y $[resmod] $W=600n $L=92.7u m=1 trise=0 ncorners=12 flg_local_she=-1
CC0 AN VSS capmod trise=0 area=4.8e-11 perim=3.2e-05 m=1
MM0 AN A VSS nch W=1u L=600n m=1 trise=0 flg_local_she=-1
MM1 Y AN VSS nch W=1u L=600n m=1 trise=0 flg_local_she=-1
.ENDS

************************************************************************
* auCdl Netlist:
*
* Library Name:  tft3d_sc_t5
* Top Cell Name: DLY4_X1PC_T5
* View Name:     schematic
* Netlisted on:  Mar  3 13:34:25 2026
************************************************************************

*.EQUATION
*.SCALE METER
*.MEGA
.PARAM

************************************************************************
* Library Name: tft3d_sc_t5
* Cell Name:    DLY4_X1PC_T5
* View Name:    schematic
************************************************************************

.SUBCKT DLY4_X1PC_T5 A Y VDD VSS
*.PININFO A:I Y:O VDD:B VSS:B
RR1 VDD ANN $[resmod] $W=600n $L=92.7u m=1 trise=0 ncorners=12 flg_local_she=-1
RR0 VDD AN $[resmod] $W=600n $L=91.4u m=1 trise=0 ncorners=10 flg_local_she=-1
CC0 AN VSS capmod trise=0 area=4.8e-11 perim=2.8e-05 m=1
MM3 Y AN VSS nch W=1u L=1.2u m=1 trise=0 flg_local_she=-1
MM2 VDD ANN Y nch W=1u L=1.2u m=1 trise=0 flg_local_she=-1
MM1 ANN AN VSS nch W=1u L=600n m=1 trise=0 flg_local_she=-1
MM0 AN A VSS nch W=1u L=1.2u m=1 trise=0 flg_local_she=-1
.ENDS

************************************************************************
* auCdl Netlist:
*
* Library Name:  tft3d_sc_t5
* Top Cell Name: DLY4_X1RL_T5
* View Name:     schematic
* Netlisted on:  Mar  3 13:34:34 2026
************************************************************************

*.EQUATION
*.SCALE METER
*.MEGA
.PARAM

************************************************************************
* Library Name: tft3d_sc_t5
* Cell Name:    DLY4_X1RL_T5
* View Name:    schematic
************************************************************************

.SUBCKT DLY4_X1RL_T5 Y VDD VSS A
*.PININFO A:I Y:O VDD:B VSS:B
RR1 VDD Y $[resmod] $W=600n $L=88.9u m=1 trise=0 ncorners=10 flg_local_she=-1
RR0 VDD AN $[resmod] $W=600n $L=20.1u m=1 trise=0 ncorners=4 flg_local_she=-1
CC0 AN VSS capmod trise=0 area=4.8e-11 perim=3.2e-05 m=1
MM1 Y AN VSS nch W=1u L=600n m=1 trise=0 flg_local_she=-1
MM0 AN A VSS nch W=1u L=600n m=1 trise=0 flg_local_she=-1
.ENDS

************************************************************************
* auCdl Netlist:
*
* Library Name:  tft3d_sc_t5
* Top Cell Name: FILLCAP1_T5
* View Name:     schematic
* Netlisted on:  Mar  3 13:34:49 2026
************************************************************************

*.EQUATION
*.SCALE METER
*.MEGA
.PARAM

************************************************************************
* Library Name: tft3d_sc_t5
* Cell Name:    FILLCAP1_T5
* View Name:    schematic
************************************************************************

.SUBCKT FILLCAP1_T5 VDD VSS
*.PININFO VDD:B VSS:B
CC0 VDD VSS capmod trise=0 area=3.1e-11 perim=3.5e-05 m=1
.ENDS

************************************************************************
* auCdl Netlist:
*
* Library Name:  tft3d_sc_t5
* Top Cell Name: FILLCAP2_T5
* View Name:     schematic
* Netlisted on:  Mar  3 13:34:51 2026
************************************************************************

*.EQUATION
*.SCALE METER
*.MEGA
.PARAM

************************************************************************
* Library Name: tft3d_sc_t5
* Cell Name:    FILLCAP2_T5
* View Name:    schematic
************************************************************************

.SUBCKT FILLCAP2_T5 VDD VSS
*.PININFO VDD:B VSS:B
CC0 VDD VSS capmod trise=0 area=9.3e-11 perim=4.3e-05 m=1
.ENDS

************************************************************************
* auCdl Netlist:
*
* Library Name:  tft3d_sc_t5
* Top Cell Name: FILLCAP4_T5
* View Name:     schematic
* Netlisted on:  Mar  3 13:34:53 2026
************************************************************************

*.EQUATION
*.SCALE METER
*.MEGA
.PARAM

************************************************************************
* Library Name: tft3d_sc_t5
* Cell Name:    FILLCAP4_T5
* View Name:    schematic
************************************************************************

.SUBCKT FILLCAP4_T5 VDD VSS
*.PININFO VDD:B VSS:B
CC0 VDD VSS capmod trise=0 area=2.17e-10 perim=5.9e-05 m=1
.ENDS

************************************************************************
* auCdl Netlist:
*
* Library Name:  tft3d_sc_t5
* Top Cell Name: FILLCAP8_T5
* View Name:     schematic
* Netlisted on:  Mar  3 13:34:55 2026
************************************************************************

*.EQUATION
*.SCALE METER
*.MEGA
.PARAM

************************************************************************
* Library Name: tft3d_sc_t5
* Cell Name:    FILLCAP8_T5
* View Name:    schematic
************************************************************************

.SUBCKT FILLCAP8_T5 VDD VSS
*.PININFO VDD:B VSS:B
CC0 VDD VSS capmod trise=0 area=4.65e-10 perim=9.1e-05 m=1
.ENDS

************************************************************************
* auCdl Netlist:
*
* Library Name:  tft3d_sc_t5
* Top Cell Name: HA_X1RL_T5
* View Name:     schematic
* Netlisted on:  Mar  3 13:34:58 2026
************************************************************************

*.EQUATION
*.SCALE METER
*.MEGA
.PARAM

************************************************************************
* Library Name: tft3d_sc_t5
* Cell Name:    HA_X1RL_T5
* View Name:    schematic
************************************************************************

.SUBCKT HA_X1RL_T5 A B CO S VDD VSS
*.PININFO A:I B:I CO:O S:O VDD:B VSS:B
MM5 net23 A VSS nch W=1u L=600n m=1 trise=0 flg_local_she=-1
MM6 net23 B VSS nch W=1u L=600n m=1 trise=0 flg_local_she=-1
MM0 net28 B VSS nch W=1u L=600n m=1 trise=0 flg_local_she=-1
MM1 CO_BAR A net28 nch W=1u L=600n m=1 trise=0 flg_local_she=-1
MM4 S S_BAR VSS nch W=1u L=600n m=1 trise=0 flg_local_she=-1
MM2 CO CO_BAR VSS nch W=1u L=600n m=1 trise=0 flg_local_she=-1
MM3 S_BAR CO_BAR net23 nch W=1u L=600n m=1 trise=0 flg_local_she=-1
RR2 VDD S_BAR $[resmod] $W=600n $L=96.4u m=1 trise=0 ncorners=12
+ flg_local_she=-1
RR1 VDD CO $[resmod] $W=600n $L=90.6u m=1 trise=0 ncorners=10 flg_local_she=-1
RR0 VDD CO_BAR $[resmod] $W=600n $L=92.7u m=1 trise=0 ncorners=12
+ flg_local_she=-1
RR3 VDD S $[resmod] $W=600n $L=99.8u m=1 trise=0 ncorners=18 flg_local_she=-1
.ENDS

************************************************************************
* auCdl Netlist:
*
* Library Name:  tft3d_sc_t5
* Top Cell Name: HA_X2RL_T5
* View Name:     schematic
* Netlisted on:  Mar  3 13:35:02 2026
************************************************************************

*.EQUATION
*.SCALE METER
*.MEGA
.PARAM

************************************************************************
* Library Name: tft3d_sc_t5
* Cell Name:    HA_X2RL_T5
* View Name:    schematic
************************************************************************

.SUBCKT HA_X2RL_T5 A B CO S VDD VSS
*.PININFO A:I B:I CO:O S:O VDD:B VSS:B
MM5 net23 A VSS nch W=1u L=600n m=1 trise=0 flg_local_she=-1
MM6 net23 B VSS nch W=1u L=600n m=1 trise=0 flg_local_she=-1
MM0 net28 B VSS nch W=1u L=600n m=1 trise=0 flg_local_she=-1
MM1 CO_BAR A net28 nch W=1u L=600n m=1 trise=0 flg_local_she=-1
MM4 S S_BAR VSS nch W=1u L=600n m=1 trise=0 flg_local_she=-1
MM2 CO CO_BAR VSS nch W=1u L=600n m=1 trise=0 flg_local_she=-1
MM3 S_BAR CO_BAR net23 nch W=1u L=600n m=1 trise=0 flg_local_she=-1
RR2 VDD S_BAR $[resmod] $W=600n $L=96.4u m=1 trise=0 ncorners=16
+ flg_local_she=-1
RR1 VDD CO $[resmod] $W=600n $L=90.6u m=1 trise=0 ncorners=10 flg_local_she=-1
RR0 VDD CO_BAR $[resmod] $W=600n $L=92.7u m=1 trise=0 ncorners=12
+ flg_local_she=-1
RR3 VDD S $[resmod] $W=600n $L=50.6u m=1 trise=0 ncorners=10 flg_local_she=-1
.ENDS

************************************************************************
* auCdl Netlist:
*
* Library Name:  tft3d_sc_t5
* Top Cell Name: HA_X4RL_T5
* View Name:     schematic
* Netlisted on:  Mar  3 13:35:04 2026
************************************************************************

*.EQUATION
*.SCALE METER
*.MEGA
.PARAM

************************************************************************
* Library Name: tft3d_sc_t5
* Cell Name:    HA_X4RL_T5
* View Name:    schematic
************************************************************************

.SUBCKT HA_X4RL_T5 A B CO S VDD VSS
*.PININFO A:I B:I CO:O S:O VDD:B VSS:B
MM5 net23 A VSS nch W=1u L=600n m=1 trise=0 flg_local_she=-1
MM6 net23 B VSS nch W=1u L=600n m=1 trise=0 flg_local_she=-1
MM0 net28 B VSS nch W=1u L=600n m=1 trise=0 flg_local_she=-1
MM1 CO_BAR A net28 nch W=1u L=600n m=1 trise=0 flg_local_she=-1
MM4 S S_BAR VSS nch W=1u L=600n m=1 trise=0 flg_local_she=-1
MM2 CO CO_BAR VSS nch W=1u L=600n m=1 trise=0 flg_local_she=-1
MM3 S_BAR CO_BAR net23 nch W=1u L=600n m=1 trise=0 flg_local_she=-1
RR2 VDD S_BAR $[resmod] $W=600n $L=92.7u m=1 trise=0 ncorners=12
+ flg_local_she=-1
RR1 VDD CO $[resmod] $W=600n $L=90.6u m=1 trise=0 ncorners=10 flg_local_she=-1
RR0 VDD CO_BAR $[resmod] $W=600n $L=92.7u m=1 trise=0 ncorners=12
+ flg_local_she=-1
RR3 VDD S $[resmod] $W=600n $L=24.1u m=1 trise=0 ncorners=4 flg_local_she=-1
.ENDS

************************************************************************
* auCdl Netlist:
*
* Library Name:  tft3d_sc_t5
* Top Cell Name: INV_X1PC_T5
* View Name:     schematic
* Netlisted on:  Mar  3 13:35:12 2026
************************************************************************

*.EQUATION
*.SCALE METER
*.MEGA
.PARAM

************************************************************************
* Library Name: tft3d_sc_t5
* Cell Name:    INV_X1PC_T5
* View Name:    schematic
************************************************************************

.SUBCKT INV_X1PC_T5 A VDD VSS Y
*.PININFO A:I Y:O VDD:B VSS:B
RR0 VDD AN $[resmod] $W=600n $L=92.6u m=1 trise=0 ncorners=12 flg_local_she=-1
MM1 VDD AN Y nch W=1u L=600n m=1 trise=0 flg_local_she=-1
MM2 Y A VSS nch W=1u L=600n m=1 trise=0 flg_local_she=-1
MM0 AN A VSS nch W=1u L=600n m=1 trise=0 flg_local_she=-1
.ENDS

************************************************************************
* auCdl Netlist:
*
* Library Name:  tft3d_sc_t5
* Top Cell Name: INV_X1RL_T5
* View Name:     schematic
* Netlisted on:  Mar  3 13:35:19 2026
************************************************************************

*.EQUATION
*.SCALE METER
*.MEGA
.PARAM

************************************************************************
* Library Name: tft3d_sc_t5
* Cell Name:    INV_X1RL_T5
* View Name:    schematic
************************************************************************

.SUBCKT INV_X1RL_T5 A VDD VSS Y
*.PININFO A:I Y:O VDD:B VSS:B
RR0 VDD Y $[resmod] $W=600n $L=92.2u m=1 trise=0 ncorners=13 flg_local_she=-1
MM0 Y A VSS nch W=1u L=600n m=1 trise=0 flg_local_she=-1
.ENDS

************************************************************************
* auCdl Netlist:
*
* Library Name:  tft3d_sc_t5
* Top Cell Name: INV_X2PC_T5
* View Name:     schematic
* Netlisted on:  Mar  3 13:35:21 2026
************************************************************************

*.EQUATION
*.SCALE METER
*.MEGA
.PARAM

************************************************************************
* Library Name: tft3d_sc_t5
* Cell Name:    INV_X2PC_T5
* View Name:    schematic
************************************************************************

.SUBCKT INV_X2PC_T5 A VDD VSS Y
*.PININFO A:I Y:O VDD:B VSS:B
RR0 VDD AN $[resmod] $W=600n $L=92.6u m=1 trise=0 ncorners=12 flg_local_she=-1
MM1 VDD AN Y nch W=2u L=600n m=1 trise=0 flg_local_she=-1
MM2 Y A VSS nch W=2u L=600n m=1 trise=0 flg_local_she=-1
MM0 AN A VSS nch W=1u L=600n m=1 trise=0 flg_local_she=-1
.ENDS

************************************************************************
* auCdl Netlist:
*
* Library Name:  tft3d_sc_t5
* Top Cell Name: INV_X2RL_T5
* View Name:     schematic
* Netlisted on:  Mar  3 13:35:23 2026
************************************************************************

*.EQUATION
*.SCALE METER
*.MEGA
.PARAM

************************************************************************
* Library Name: tft3d_sc_t5
* Cell Name:    INV_X2RL_T5
* View Name:    schematic
************************************************************************

.SUBCKT INV_X2RL_T5 A VDD VSS Y
*.PININFO A:I Y:O VDD:B VSS:B
RR0 VDD Y $[resmod] $W=600n $L=52.6u m=1 trise=0 ncorners=13 flg_local_she=-1
MM0 Y A VSS nch W=1u L=600n m=1 trise=0 flg_local_she=-1
.ENDS

************************************************************************
* auCdl Netlist:
*
* Library Name:  tft3d_sc_t5
* Top Cell Name: INV_X4PC_T5
* View Name:     schematic
* Netlisted on:  Mar  3 13:35:24 2026
************************************************************************

*.EQUATION
*.SCALE METER
*.MEGA
.PARAM

************************************************************************
* Library Name: tft3d_sc_t5
* Cell Name:    INV_X4PC_T5
* View Name:    schematic
************************************************************************

.SUBCKT INV_X4PC_T5 A VDD VSS Y
*.PININFO A:I Y:O VDD:B VSS:B
RR0 VDD AN $[resmod] $W=600n $L=24.1u m=1 trise=0 ncorners=3 flg_local_she=-1
MM1 VDD AN Y nch W=4u L=600n m=1 trise=0 flg_local_she=-1
MM2 Y A VSS nch W=4u L=600n m=1 trise=0 flg_local_she=-1
MM0 AN A VSS nch W=4u L=600n m=1 trise=0 flg_local_she=-1
.ENDS

************************************************************************
* auCdl Netlist:
*
* Library Name:  tft3d_sc_t5
* Top Cell Name: INV_X4RL_T5
* View Name:     schematic
* Netlisted on:  Mar  3 13:35:31 2026
************************************************************************

*.EQUATION
*.SCALE METER
*.MEGA
.PARAM

************************************************************************
* Library Name: tft3d_sc_t5
* Cell Name:    INV_X4RL_T5
* View Name:    schematic
************************************************************************

.SUBCKT INV_X4RL_T5 A VDD VSS Y
*.PININFO A:I Y:O VDD:B VSS:B
RR2 VDD Y $[resmod] $W=600n $L=24.1u m=1 trise=0 ncorners=4 flg_local_she=-1
MM0 Y A VSS nch W=1u L=600n m=1 trise=0 flg_local_she=-1
.ENDS

************************************************************************
* auCdl Netlist:
*
* Library Name:  tft3d_sc_t5
* Top Cell Name: LAT_X1PC_T5
* View Name:     schematic
* Netlisted on:  Mar  3 13:35:37 2026
************************************************************************

*.EQUATION
*.SCALE METER
*.MEGA
.PARAM

************************************************************************
* Library Name: tft3d_sc_t5
* Cell Name:    LAT_X1PC_T5
* View Name:    schematic
************************************************************************

.SUBCKT LAT_X1PC_T5 D E Q QN VDD VSS
*.PININFO D:I E:I Q:O QN:O VDD:B VSS:B
RR0 VDD EN $[resmod] $W=600n $L=90.6u m=1 trise=0 ncorners=12 flg_local_she=-1
RR1 VDD ENN $[resmod] $W=600n $L=96.4u m=1 trise=0 ncorners=16 flg_local_she=-1
RR3 VDD L $[resmod] $W=600n $L=96.4u m=1 trise=0 ncorners=16 flg_local_she=-1
RR2 VDD LN $[resmod] $W=600n $L=92.6u m=1 trise=0 ncorners=12 flg_local_she=-1
MM6 VDD LN QN nch W=1u L=600n m=1 trise=0 flg_local_she=-1
MM8 VDD L Q nch W=1u L=600n m=1 trise=0 flg_local_she=-1
MM7 QN L VSS nch W=1u L=600n m=1 trise=0 flg_local_she=-1
MM9 Q LN VSS nch W=1u L=600n m=1 trise=0 flg_local_she=-1
MM2 D ENN D_ nch W=1u L=600n m=1 trise=0 flg_local_she=-1
MM4 LN D_ VSS nch W=1u L=600n m=1 trise=0 flg_local_she=-1
MM3 D_ EN L nch W=1u L=600n m=1 trise=0 flg_local_she=-1
MM5 L LN VSS nch W=1u L=600n m=1 trise=0 flg_local_she=-1
MM1 ENN EN VSS nch W=1u L=600n m=1 trise=0 flg_local_she=-1
MM0 EN E VSS nch W=1u L=600n m=1 trise=0 flg_local_she=-1
.ENDS

************************************************************************
* auCdl Netlist:
*
* Library Name:  tft3d_sc_t5
* Top Cell Name: LAT_X2PC_T5
* View Name:     schematic
* Netlisted on:  Mar  3 13:35:45 2026
************************************************************************

*.EQUATION
*.SCALE METER
*.MEGA
.PARAM

************************************************************************
* Library Name: tft3d_sc_t5
* Cell Name:    LAT_X2PC_T5
* View Name:    schematic
************************************************************************

.SUBCKT LAT_X2PC_T5 D E Q QN VDD VSS
*.PININFO D:I E:I Q:O QN:O VDD:B VSS:B
RR2 VDD LN $[resmod] $W=600n $L=52.6u m=1 trise=0 ncorners=10 flg_local_she=-1
RR3 VDD L $[resmod] $W=600n $L=50.4u m=1 trise=0 ncorners=8 flg_local_she=-1
RR0 VDD EN $[resmod] $W=600n $L=90.6u m=1 trise=0 ncorners=14 flg_local_she=-1
RR1 VDD ENN $[resmod] $W=600n $L=96.4u m=1 trise=0 ncorners=16 flg_local_she=-1
MM0 EN E VSS nch W=1u L=600n m=1 trise=0 flg_local_she=-1
MM1 ENN EN VSS nch W=1u L=600n m=1 trise=0 flg_local_she=-1
MM5 L LN VSS nch W=1u L=600n m=1 trise=0 flg_local_she=-1
MM3 D_ EN L nch W=1u L=600n m=1 trise=0 flg_local_she=-1
MM4 LN D_ VSS nch W=1u L=600n m=1 trise=0 flg_local_she=-1
MM2 D ENN D_ nch W=1u L=600n m=1 trise=0 flg_local_she=-1
MM9 Q LN VSS nch W=2u L=600n m=1 trise=0 flg_local_she=-1
MM7 QN L VSS nch W=2u L=600n m=1 trise=0 flg_local_she=-1
MM8 VDD L Q nch W=2u L=600n m=1 trise=0 flg_local_she=-1
MM6 VDD LN QN nch W=2u L=600n m=1 trise=0 flg_local_she=-1
.ENDS

************************************************************************
* auCdl Netlist:
*
* Library Name:  tft3d_sc_t5
* Top Cell Name: LAT_X4PC_T5
* View Name:     schematic
* Netlisted on:  Mar  3 13:35:56 2026
************************************************************************

*.EQUATION
*.SCALE METER
*.MEGA
.PARAM

************************************************************************
* Library Name: tft3d_sc_t5
* Cell Name:    LAT_X4PC_T5
* View Name:    schematic
************************************************************************

.SUBCKT LAT_X4PC_T5 D E Q QN VDD VSS
*.PININFO D:I E:I Q:O QN:O VDD:B VSS:B
RR1 VDD ENN $[resmod] $W=600n $L=96.4u m=1 trise=0 ncorners=16 flg_local_she=-1
RR0 VDD EN $[resmod] $W=600n $L=90.6u m=1 trise=0 ncorners=16 flg_local_she=-1
RR3 VDD L $[resmod] $W=600n $L=24.1u m=1 trise=0 ncorners=4 flg_local_she=-1
RR2 VDD LN $[resmod] $W=600n $L=24.1u m=1 trise=0 ncorners=4 flg_local_she=-1
MM6 VDD LN QN nch W=4u L=600n m=1 trise=0 flg_local_she=-1
MM8 VDD L Q nch W=4u L=600n m=1 trise=0 flg_local_she=-1
MM7 QN L VSS nch W=4u L=600n m=1 trise=0 flg_local_she=-1
MM9 Q LN VSS nch W=4u L=600n m=1 trise=0 flg_local_she=-1
MM2 D ENN D_ nch W=1u L=600n m=1 trise=0 flg_local_she=-1
MM4 LN D_ VSS nch W=1u L=600n m=1 trise=0 flg_local_she=-1
MM3 D_ EN L nch W=1u L=600n m=1 trise=0 flg_local_she=-1
MM5 L LN VSS nch W=1u L=600n m=1 trise=0 flg_local_she=-1
MM1 ENN EN VSS nch W=1u L=600n m=1 trise=0 flg_local_she=-1
MM0 EN E VSS nch W=1u L=600n m=1 trise=0 flg_local_she=-1
.ENDS

************************************************************************
* auCdl Netlist:
*
* Library Name:  tft3d_sc_t5
* Top Cell Name: MX2_X1RL_T5
* View Name:     schematic
* Netlisted on:  Mar  3 13:36:00 2026
************************************************************************

*.EQUATION
*.SCALE METER
*.MEGA
.PARAM

************************************************************************
* Library Name: tft3d_sc_t5
* Cell Name:    MX2_X1RL_T5
* View Name:    schematic
************************************************************************

.SUBCKT MX2_X1RL_T5 A B S VDD VSS Y
*.PININFO A:I B:I S:I Y:O VDD:B VSS:B
RR0 VDD Sbar $[resmod] $W=600n $L=96.4u m=1 trise=0 ncorners=16
+ flg_local_she=-1
RR2 VDD Y $[resmod] $W=600n $L=95.0u m=1 trise=0 ncorners=14 flg_local_she=-1
RR1 VDD Xbar $[resmod] $W=600n $L=95.0u m=1 trise=0 ncorners=14
+ flg_local_she=-1
MM5 Sbar S VSS nch W=1u L=600n m=1 trise=0 flg_local_she=-1
MM4 net18 S VSS nch W=1u L=600n m=1 trise=0 flg_local_she=-1
MM3 net19 Sbar VSS nch W=1u L=600n m=1 trise=0 flg_local_she=-1
MM2 Y Xbar VSS nch W=1u L=600n m=1 trise=0 flg_local_she=-1
MM1 Xbar B net18 nch W=1u L=600n m=1 trise=0 flg_local_she=-1
MM0 Xbar A net19 nch W=1u L=600n m=1 trise=0 flg_local_she=-1
.ENDS

************************************************************************
* auCdl Netlist:
*
* Library Name:  tft3d_sc_t5
* Top Cell Name: MX2_X2RL_T5
* View Name:     schematic
* Netlisted on:  Mar  3 13:36:03 2026
************************************************************************

*.EQUATION
*.SCALE METER
*.MEGA
.PARAM

************************************************************************
* Library Name: tft3d_sc_t5
* Cell Name:    MX2_X2RL_T5
* View Name:    schematic
************************************************************************

.SUBCKT MX2_X2RL_T5 A B S VDD VSS Y
*.PININFO A:I B:I S:I Y:O VDD:B VSS:B
RR0 VDD Sbar $[resmod] $W=600n $L=96.4u m=1 trise=0 ncorners=16
+ flg_local_she=-1
RR2 VDD Y $[resmod] $W=600n $L=54.2u m=1 trise=0 ncorners=14 flg_local_she=-1
RR1 VDD Xbar $[resmod] $W=600n $L=95.0u m=1 trise=0 ncorners=14
+ flg_local_she=-1
MM5 Sbar S VSS nch W=1u L=600n m=1 trise=0 flg_local_she=-1
MM4 net18 S VSS nch W=1u L=600n m=1 trise=0 flg_local_she=-1
MM3 net19 Sbar VSS nch W=1u L=600n m=1 trise=0 flg_local_she=-1
MM2 Y Xbar VSS nch W=1u L=600n m=1 trise=0 flg_local_she=-1
MM1 Xbar B net18 nch W=1u L=600n m=1 trise=0 flg_local_she=-1
MM0 Xbar A net19 nch W=1u L=600n m=1 trise=0 flg_local_she=-1
.ENDS

************************************************************************
* auCdl Netlist:
*
* Library Name:  tft3d_sc_t5
* Top Cell Name: MX2_X4RL_T5
* View Name:     schematic
* Netlisted on:  Mar  3 13:36:13 2026
************************************************************************

*.EQUATION
*.SCALE METER
*.MEGA
.PARAM

************************************************************************
* Library Name: tft3d_sc_t5
* Cell Name:    MX2_X4RL_T5
* View Name:    schematic
************************************************************************

.SUBCKT MX2_X4RL_T5 A B S VDD VSS Y
*.PININFO A:I B:I S:I Y:O VDD:B VSS:B
RR0 VDD Sbar $[resmod] $W=600n $L=96.4u m=1 trise=0 ncorners=16
+ flg_local_she=-1
RR2 VDD Y $[resmod] $W=600n $L=26.2u m=1 trise=0 ncorners=4 flg_local_she=-1
RR1 VDD Xbar $[resmod] $W=600n $L=95.0u m=1 trise=0 ncorners=14
+ flg_local_she=-1
MM5 Sbar S VSS nch W=1u L=600n m=1 trise=0 flg_local_she=-1
MM4 net18 S VSS nch W=1u L=600n m=1 trise=0 flg_local_she=-1
MM3 net19 Sbar VSS nch W=1u L=600n m=1 trise=0 flg_local_she=-1
MM2 Y Xbar VSS nch W=1u L=600n m=1 trise=0 flg_local_she=-1
MM1 Xbar B net18 nch W=1u L=600n m=1 trise=0 flg_local_she=-1
MM0 Xbar A net19 nch W=1u L=600n m=1 trise=0 flg_local_she=-1
.ENDS

************************************************************************
* auCdl Netlist:
*
* Library Name:  tft3d_sc_t5
* Top Cell Name: MXI2_X1RL_T5
* View Name:     schematic
* Netlisted on:  Mar  3 13:36:20 2026
************************************************************************

*.EQUATION
*.SCALE METER
*.MEGA
.PARAM

************************************************************************
* Library Name: tft3d_sc_t5
* Cell Name:    MXI2_X1RL_T5
* View Name:    schematic
************************************************************************

.SUBCKT MXI2_X1RL_T5 A B S VDD VSS Y
*.PININFO A:I B:I S:I Y:O VDD:B VSS:B
RR0 VDD Sbar $[resmod] $W=600n $L=93.0u m=1 trise=0 ncorners=12
+ flg_local_she=-1
RR1 VDD Y $[resmod] $W=600n $L=92.6u m=1 trise=0 ncorners=12 flg_local_she=-1
MM5 Sbar S VSS nch W=1u L=600n m=1 trise=0 flg_local_she=-1
MM4 net18 S VSS nch W=1u L=600n m=1 trise=0 flg_local_she=-1
MM3 net19 Sbar VSS nch W=1u L=600n m=1 trise=0 flg_local_she=-1
MM1 Y B net18 nch W=1u L=600n m=1 trise=0 flg_local_she=-1
MM0 Y A net19 nch W=1u L=600n m=1 trise=0 flg_local_she=-1
.ENDS

************************************************************************
* auCdl Netlist:
*
* Library Name:  tft3d_sc_t5
* Top Cell Name: MXI2_X2RL_T5
* View Name:     schematic
* Netlisted on:  Mar  3 13:36:21 2026
************************************************************************

*.EQUATION
*.SCALE METER
*.MEGA
.PARAM

************************************************************************
* Library Name: tft3d_sc_t5
* Cell Name:    MXI2_X2RL_T5
* View Name:    schematic
************************************************************************

.SUBCKT MXI2_X2RL_T5 A B S VDD VSS Y
*.PININFO A:I B:I S:I Y:O VDD:B VSS:B
RR0 VDD Sbar $[resmod] $W=600n $L=92.5u m=1 trise=0 ncorners=12
+ flg_local_she=-1
RR1 VDD Y $[resmod] $W=600n $L=48.2u m=1 trise=0 ncorners=8 flg_local_she=-1
MM5 Sbar S VSS nch W=1u L=600n m=1 trise=0 flg_local_she=-1
MM4 net18 S VSS nch W=1u L=600n m=1 trise=0 flg_local_she=-1
MM3 net19 Sbar VSS nch W=1u L=600n m=1 trise=0 flg_local_she=-1
MM1 Y B net18 nch W=1u L=600n m=1 trise=0 flg_local_she=-1
MM0 Y A net19 nch W=1u L=600n m=1 trise=0 flg_local_she=-1
.ENDS

************************************************************************
* auCdl Netlist:
*
* Library Name:  tft3d_sc_t5
* Top Cell Name: MXI2_X4RL_T5
* View Name:     schematic
* Netlisted on:  Mar  3 13:36:26 2026
************************************************************************

*.EQUATION
*.SCALE METER
*.MEGA
.PARAM

************************************************************************
* Library Name: tft3d_sc_t5
* Cell Name:    MXI2_X4RL_T5
* View Name:    schematic
************************************************************************

.SUBCKT MXI2_X4RL_T5 A B S VDD VSS Y
*.PININFO A:I B:I S:I Y:O VDD:B VSS:B
RR0 VDD Sbar $[resmod] $W=600n $L=93.1u m=1 trise=0 ncorners=12
+ flg_local_she=-1
RR1 VDD Y $[resmod] $W=600n $L=24.1u m=1 trise=0 ncorners=4 flg_local_she=-1
MM5 Sbar S VSS nch W=1u L=600n m=1 trise=0 flg_local_she=-1
MM4 net18 S VSS nch W=2u L=600n m=1 trise=0 flg_local_she=-1
MM3 net19 Sbar VSS nch W=2u L=600n m=1 trise=0 flg_local_she=-1
MM1 Y B net18 nch W=2u L=600n m=1 trise=0 flg_local_she=-1
MM0 Y A net19 nch W=2u L=600n m=1 trise=0 flg_local_she=-1
.ENDS

************************************************************************
* auCdl Netlist:
*
* Library Name:  tft3d_sc_t5
* Top Cell Name: NAND2_X0P7RL_T5
* View Name:     schematic
* Netlisted on:  Mar  3 13:36:35 2026
************************************************************************

*.EQUATION
*.SCALE METER
*.MEGA
.PARAM

************************************************************************
* Library Name: tft3d_sc_t5
* Cell Name:    NAND2_X0P7RL_T5
* View Name:    schematic
************************************************************************

.SUBCKT NAND2_X0P7RL_T5 A1 A2 VDD VSS Y
*.PININFO A1:I A2:I Y:O VDD:B VSS:B
RR0 VDD Y $[resmod] $W=600n $L=132.2u m=1 trise=0 ncorners=20 flg_local_she=-1
MM1 net12 A2 VSS nch W=1u L=600n m=1 trise=0 flg_local_she=-1
MM0 Y A1 net12 nch W=1u L=600n m=1 trise=0 flg_local_she=-1
.ENDS

************************************************************************
* auCdl Netlist:
*
* Library Name:  tft3d_sc_t5
* Top Cell Name: NAND2_X1RL_T5
* View Name:     schematic
* Netlisted on:  Mar  3 13:36:36 2026
************************************************************************

*.EQUATION
*.SCALE METER
*.MEGA
.PARAM

************************************************************************
* Library Name: tft3d_sc_t5
* Cell Name:    NAND2_X1RL_T5
* View Name:    schematic
************************************************************************

.SUBCKT NAND2_X1RL_T5 A1 A2 VDD VSS Y
*.PININFO A1:I A2:I Y:O VDD:B VSS:B
RR0 VDD Y $[resmod] $W=600n $L=97.0u m=1 trise=0 ncorners=18 flg_local_she=-1
MM1 net12 A2 VSS nch W=1u L=600n m=1 trise=0 flg_local_she=-1
MM0 Y A1 net12 nch W=1u L=600n m=1 trise=0 flg_local_she=-1
.ENDS

************************************************************************
* auCdl Netlist:
*
* Library Name:  tft3d_sc_t5
* Top Cell Name: NAND2_X2RL_T5
* View Name:     schematic
* Netlisted on:  Mar  3 13:36:45 2026
************************************************************************

*.EQUATION
*.SCALE METER
*.MEGA
.PARAM

************************************************************************
* Library Name: tft3d_sc_t5
* Cell Name:    NAND2_X2RL_T5
* View Name:    schematic
************************************************************************

.SUBCKT NAND2_X2RL_T5 A1 A2 VDD VSS Y
*.PININFO A1:I A2:I Y:O VDD:B VSS:B
RR0 VDD Y $[resmod] $W=600n $L=48.5u m=1 trise=0 ncorners=8 flg_local_she=-1
MM0 Y A1 M0_S_M1_D nch W=1u L=600n m=1 trise=0 flg_local_she=-1
MM1 M0_S_M1_D A2 VSS nch W=1u L=600n m=1 trise=0 flg_local_she=-1
.ENDS

************************************************************************
* auCdl Netlist:
*
* Library Name:  tft3d_sc_t5
* Top Cell Name: NAND2_X4RL_T5
* View Name:     schematic
* Netlisted on:  Mar  3 13:36:50 2026
************************************************************************

*.EQUATION
*.SCALE METER
*.MEGA
.PARAM

************************************************************************
* Library Name: tft3d_sc_t5
* Cell Name:    NAND2_X4RL_T5
* View Name:    schematic
************************************************************************

.SUBCKT NAND2_X4RL_T5 A1 A2 VDD VSS Y
*.PININFO A1:I A2:I Y:O VDD:B VSS:B
RR0 VDD Y $[resmod] $W=600n $L=29.0u m=1 trise=0 ncorners=8 flg_local_she=-1
MM0 Y A1 M0_S_M1_D nch W=2u L=600n m=1 trise=0 flg_local_she=-1
MM1 M0_S_M1_D A2 VSS nch W=2u L=600n m=1 trise=0 flg_local_she=-1
.ENDS

************************************************************************
* auCdl Netlist:
*
* Library Name:  tft3d_sc_t5
* Top Cell Name: NAND3_X1RL_T5
* View Name:     schematic
* Netlisted on:  Mar  3 13:36:59 2026
************************************************************************

*.EQUATION
*.SCALE METER
*.MEGA
.PARAM

************************************************************************
* Library Name: tft3d_sc_t5
* Cell Name:    NAND3_X1RL_T5
* View Name:    schematic
************************************************************************

.SUBCKT NAND3_X1RL_T5 A1 A2 A3 VDD VSS Y
*.PININFO A1:I A2:I A3:I Y:O VDD:B VSS:B
RR0 VDD Y $[resmod] $W=600n $L=92.7u m=1 trise=0 ncorners=12 flg_local_she=-1
MM2 net14 A3 VSS nch W=1u L=600n m=1 trise=0 flg_local_she=-1
MM0 Y A1 net15 nch W=1u L=600n m=1 trise=0 flg_local_she=-1
MM1 net15 A2 net14 nch W=1u L=600n m=1 trise=0 flg_local_she=-1
.ENDS

************************************************************************
* auCdl Netlist:
*
* Library Name:  tft3d_sc_t5
* Top Cell Name: NAND3_X2RL_T5
* View Name:     schematic
* Netlisted on:  Mar  3 13:37:05 2026
************************************************************************

*.EQUATION
*.SCALE METER
*.MEGA
.PARAM

************************************************************************
* Library Name: tft3d_sc_t5
* Cell Name:    NAND3_X2RL_T5
* View Name:    schematic
************************************************************************

.SUBCKT NAND3_X2RL_T5 A1 A2 A3 VDD VSS Y
*.PININFO A1:I A2:I A3:I Y:O VDD:B VSS:B
RR0 VDD Y $[resmod] $W=600n $L=48.5u m=1 trise=0 ncorners=8 flg_local_she=-1
MM2 net14 A3 VSS nch W=1u L=600n m=1 trise=0 flg_local_she=-1
MM0 Y A1 net15 nch W=1u L=600n m=1 trise=0 flg_local_she=-1
MM1 net15 A2 net14 nch W=1u L=600n m=1 trise=0 flg_local_she=-1
.ENDS

************************************************************************
* auCdl Netlist:
*
* Library Name:  tft3d_sc_t5
* Top Cell Name: NAND3_X4RL_T5
* View Name:     schematic
* Netlisted on:  Mar  3 13:37:18 2026
************************************************************************

*.EQUATION
*.SCALE METER
*.MEGA
.PARAM

************************************************************************
* Library Name: tft3d_sc_t5
* Cell Name:    NAND3_X4RL_T5
* View Name:    schematic
************************************************************************

.SUBCKT NAND3_X4RL_T5 A1 A2 A3 VDD VSS Y
*.PININFO A1:I A2:I A3:I Y:O VDD:B VSS:B
RR0 VDD Y $[resmod] $W=600n $L=28.0u m=1 trise=0 ncorners=8 flg_local_she=-1
MM2 net14 A3 VSS nch W=2u L=600n m=1 trise=0 flg_local_she=-1
MM0 Y A1 net15 nch W=2u L=600n m=1 trise=0 flg_local_she=-1
MM1 net15 A2 net14 nch W=2u L=600n m=1 trise=0 flg_local_she=-1
.ENDS

************************************************************************
* auCdl Netlist:
*
* Library Name:  tft3d_sc_t5
* Top Cell Name: NAND4_X1RL_T5
* View Name:     schematic
* Netlisted on:  Mar  3 13:37:21 2026
************************************************************************

*.EQUATION
*.SCALE METER
*.MEGA
.PARAM

************************************************************************
* Library Name: tft3d_sc_t5
* Cell Name:    NAND4_X1RL_T5
* View Name:    schematic
************************************************************************

.SUBCKT NAND4_X1RL_T5 A1 A2 A3 A4 VDD VSS Y
*.PININFO A1:I A2:I A3:I A4:I Y:O VDD:B VSS:B
RR0 VDD Y $[resmod] $W=600n $L=92.7u m=1 trise=0 ncorners=12 flg_local_she=-1
MM3 net09 A4 VSS nch W=1u L=600n m=1 trise=0 flg_local_she=-1
MM2 net14 A3 net09 nch W=1u L=600n m=1 trise=0 flg_local_she=-1
MM0 Y A1 net15 nch W=1u L=600n m=1 trise=0 flg_local_she=-1
MM1 net15 A2 net14 nch W=1u L=600n m=1 trise=0 flg_local_she=-1
.ENDS

************************************************************************
* auCdl Netlist:
*
* Library Name:  tft3d_sc_t5
* Top Cell Name: NAND4_X2RL_T5
* View Name:     schematic
* Netlisted on:  Mar  3 13:37:27 2026
************************************************************************

*.EQUATION
*.SCALE METER
*.MEGA
.PARAM

************************************************************************
* Library Name: tft3d_sc_t5
* Cell Name:    NAND4_X2RL_T5
* View Name:    schematic
************************************************************************

.SUBCKT NAND4_X2RL_T5 A1 A2 A3 A4 VDD VSS Y
*.PININFO A1:I A2:I A3:I A4:I Y:O VDD:B VSS:B
RR0 VDD Y $[resmod] $W=600n $L=48.5u m=1 trise=0 ncorners=8 flg_local_she=-1
MM3 net09 A4 VSS nch W=2u L=600n m=1 trise=0 flg_local_she=-1
MM2 net14 A3 net09 nch W=2u L=600n m=1 trise=0 flg_local_she=-1
MM0 Y A1 net15 nch W=2u L=600n m=1 trise=0 flg_local_she=-1
MM1 net15 A2 net14 nch W=2u L=600n m=1 trise=0 flg_local_she=-1
.ENDS

************************************************************************
* auCdl Netlist:
*
* Library Name:  tft3d_sc_t5
* Top Cell Name: NOR2_X1RL_T5
* View Name:     schematic
* Netlisted on:  Mar  3 13:37:34 2026
************************************************************************

*.EQUATION
*.SCALE METER
*.MEGA
.PARAM

************************************************************************
* Library Name: tft3d_sc_t5
* Cell Name:    NOR2_X1RL_T5
* View Name:    schematic
************************************************************************

.SUBCKT NOR2_X1RL_T5 A1 A2 VDD VSS Y
*.PININFO A1:I A2:I Y:O VDD:B VSS:B
RR0 VDD Y $[resmod] $W=600n $L=95.0u m=1 trise=0 ncorners=16 flg_local_she=-1
MM1 Y A2 VSS nch W=1u L=600n m=1 trise=0 flg_local_she=-1
MM0 Y A1 VSS nch W=1u L=600n m=1 trise=0 flg_local_she=-1
.ENDS

************************************************************************
* auCdl Netlist:
*
* Library Name:  tft3d_sc_t5
* Top Cell Name: NOR2_X2RL_T5
* View Name:     schematic
* Netlisted on:  Mar  3 13:37:42 2026
************************************************************************

*.EQUATION
*.SCALE METER
*.MEGA
.PARAM

************************************************************************
* Library Name: tft3d_sc_t5
* Cell Name:    NOR2_X2RL_T5
* View Name:    schematic
************************************************************************

.SUBCKT NOR2_X2RL_T5 A1 A2 VDD VSS Y
*.PININFO A1:I A2:I Y:O VDD:B VSS:B
RR0 VDD Y $[resmod] $W=600n $L=48.4u m=1 trise=0 ncorners=8 flg_local_she=-1
MM1 Y A2 VSS nch W=1u L=600n m=1 trise=0 flg_local_she=-1
MM0 Y A1 VSS nch W=1u L=600n m=1 trise=0 flg_local_she=-1
.ENDS

************************************************************************
* auCdl Netlist:
*
* Library Name:  tft3d_sc_t5
* Top Cell Name: NOR2_X4RL_T5
* View Name:     schematic
* Netlisted on:  Mar  3 13:37:45 2026
************************************************************************

*.EQUATION
*.SCALE METER
*.MEGA
.PARAM

************************************************************************
* Library Name: tft3d_sc_t5
* Cell Name:    NOR2_X4RL_T5
* View Name:    schematic
************************************************************************

.SUBCKT NOR2_X4RL_T5 A1 A2 VDD VSS Y
*.PININFO A1:I A2:I Y:O VDD:B VSS:B
RR0 VDD Y $[resmod] $W=600n $L=24.2u m=1 trise=0 ncorners=4 flg_local_she=-1
MM1 Y A2 VSS nch W=1u L=600n m=1 trise=0 flg_local_she=-1
MM0 Y A1 VSS nch W=1u L=600n m=1 trise=0 flg_local_she=-1
.ENDS

************************************************************************
* auCdl Netlist:
*
* Library Name:  tft3d_sc_t5
* Top Cell Name: NOR3_X1RL_T5
* View Name:     schematic
* Netlisted on:  Mar  3 13:37:52 2026
************************************************************************

*.EQUATION
*.SCALE METER
*.MEGA
.PARAM

************************************************************************
* Library Name: tft3d_sc_t5
* Cell Name:    NOR3_X1RL_T5
* View Name:    schematic
************************************************************************

.SUBCKT NOR3_X1RL_T5 A1 A2 A3 VDD VSS Y
*.PININFO A1:I A2:I A3:I Y:O VDD:B VSS:B
RR0 VDD Y $[resmod] $W=600n $L=92.7u m=1 trise=0 ncorners=12 flg_local_she=-1
MM2 Y A3 VSS nch W=1u L=600n m=1 trise=0 flg_local_she=-1
MM0 Y A1 VSS nch W=1u L=600n m=1 trise=0 flg_local_she=-1
MM1 Y A2 VSS nch W=1u L=600n m=1 trise=0 flg_local_she=-1
.ENDS

************************************************************************
* auCdl Netlist:
*
* Library Name:  tft3d_sc_t5
* Top Cell Name: NOR3_X2RL_T5
* View Name:     schematic
* Netlisted on:  Mar  3 13:37:55 2026
************************************************************************

*.EQUATION
*.SCALE METER
*.MEGA
.PARAM

************************************************************************
* Library Name: tft3d_sc_t5
* Cell Name:    NOR3_X2RL_T5
* View Name:    schematic
************************************************************************

.SUBCKT NOR3_X2RL_T5 A1 A2 A3 VDD VSS Y
*.PININFO A1:I A2:I A3:I Y:O VDD:B VSS:B
RR0 VDD Y $[resmod] $W=600n $L=46.4u m=1 trise=0 ncorners=6 flg_local_she=-1
MM0 Y A1 VSS nch W=1u L=600n m=1 trise=0 flg_local_she=-1
MM1 Y A2 VSS nch W=1u L=600n m=1 trise=0 flg_local_she=-1
MM2 Y A3 VSS nch W=1u L=600n m=1 trise=0 flg_local_she=-1
.ENDS

************************************************************************
* auCdl Netlist:
*
* Library Name:  tft3d_sc_t5
* Top Cell Name: NOR3_X4RL_T5
* View Name:     schematic
* Netlisted on:  Mar  3 13:37:57 2026
************************************************************************

*.EQUATION
*.SCALE METER
*.MEGA
.PARAM

************************************************************************
* Library Name: tft3d_sc_t5
* Cell Name:    NOR3_X4RL_T5
* View Name:    schematic
************************************************************************

.SUBCKT NOR3_X4RL_T5 A1 A2 A3 VDD VSS Y
*.PININFO A1:I A2:I A3:I Y:O VDD:B VSS:B
RR0 VDD Y $[resmod] $W=600n $L=25.1u m=1 trise=0 ncorners=5 flg_local_she=-1
MM0 Y A1 VSS nch W=1u L=600n m=1 trise=0 flg_local_she=-1
MM1 Y A2 VSS nch W=1u L=600n m=1 trise=0 flg_local_she=-1
MM2 Y A3 VSS nch W=1u L=600n m=1 trise=0 flg_local_she=-1
.ENDS

************************************************************************
* auCdl Netlist:
*
* Library Name:  tft3d_sc_t5
* Top Cell Name: NOR4_X1RL_T5
* View Name:     schematic
* Netlisted on:  Mar  3 13:37:59 2026
************************************************************************

*.EQUATION
*.SCALE METER
*.MEGA
.PARAM

************************************************************************
* Library Name: tft3d_sc_t5
* Cell Name:    NOR4_X1RL_T5
* View Name:    schematic
************************************************************************

.SUBCKT NOR4_X1RL_T5 A1 A2 A3 A4 VDD VSS Y
*.PININFO A1:I A2:I A3:I A4:I Y:O VDD:B VSS:B
RR0 VDD Y $[resmod] $W=600n $L=92.9u m=1 trise=0 ncorners=12 flg_local_she=-1
MM3 Y A4 VSS nch W=1u L=600n m=1 trise=0 flg_local_she=-1
MM2 Y A3 VSS nch W=1u L=600n m=1 trise=0 flg_local_she=-1
MM0 Y A1 VSS nch W=1u L=600n m=1 trise=0 flg_local_she=-1
MM1 Y A2 VSS nch W=1u L=600n m=1 trise=0 flg_local_she=-1
.ENDS

************************************************************************
* auCdl Netlist:
*
* Library Name:  tft3d_sc_t5
* Top Cell Name: NOR4_X2RL_T5
* View Name:     schematic
* Netlisted on:  Mar  3 13:38:02 2026
************************************************************************

*.EQUATION
*.SCALE METER
*.MEGA
.PARAM

************************************************************************
* Library Name: tft3d_sc_t5
* Cell Name:    NOR4_X2RL_T5
* View Name:    schematic
************************************************************************

.SUBCKT NOR4_X2RL_T5 A1 A2 A3 A4 VDD VSS Y
*.PININFO A1:I A2:I A3:I A4:I Y:O VDD:B VSS:B
RR0 VDD Y $[resmod] $W=600n $L=46.4u m=1 trise=0 ncorners=6 flg_local_she=-1
MM3 Y A4 VSS nch W=1u L=600n m=1 trise=0 flg_local_she=-1
MM2 Y A3 VSS nch W=1u L=600n m=1 trise=0 flg_local_she=-1
MM0 Y A1 VSS nch W=1u L=600n m=1 trise=0 flg_local_she=-1
MM1 Y A2 VSS nch W=1u L=600n m=1 trise=0 flg_local_she=-1
.ENDS

************************************************************************
* auCdl Netlist:
*
* Library Name:  tft3d_sc_t5
* Top Cell Name: NOR4_X4RL_T5
* View Name:     schematic
* Netlisted on:  Mar  3 13:38:04 2026
************************************************************************

*.EQUATION
*.SCALE METER
*.MEGA
.PARAM

************************************************************************
* Library Name: tft3d_sc_t5
* Cell Name:    NOR4_X4RL_T5
* View Name:    schematic
************************************************************************

.SUBCKT NOR4_X4RL_T5 A1 A2 A3 A4 VDD VSS Y
*.PININFO A1:I A2:I A3:I A4:I Y:O VDD:B VSS:B
RR0 VDD Y $[resmod] $W=600n $L=24.1u m=1 trise=0 ncorners=4 flg_local_she=-1
MM3 Y A4 VSS nch W=1u L=600n m=1 trise=0 flg_local_she=-1
MM2 Y A3 VSS nch W=1u L=600n m=1 trise=0 flg_local_she=-1
MM0 Y A1 VSS nch W=1u L=600n m=1 trise=0 flg_local_she=-1
MM1 Y A2 VSS nch W=1u L=600n m=1 trise=0 flg_local_she=-1
.ENDS

************************************************************************
* auCdl Netlist:
*
* Library Name:  tft3d_sc_t5
* Top Cell Name: OAI211_X1RL_T5
* View Name:     schematic
* Netlisted on:  Mar  3 13:38:36 2026
************************************************************************

*.EQUATION
*.SCALE METER
*.MEGA
.PARAM

************************************************************************
* Library Name: tft3d_sc_t5
* Cell Name:    OAI211_X1RL_T5
* View Name:    schematic
************************************************************************

.SUBCKT OAI211_X1RL_T5 A1 A2 B C VDD VSS Y
*.PININFO A1:I A2:I B:I C:I Y:O VDD:B VSS:B
MM3 M0_S_M1_D A2 VSS nch W=1u L=600n m=1 trise=0 flg_local_she=-1
MM2 M0_S_M1_D A1 VSS nch W=1u L=600n m=1 trise=0 flg_local_she=-1
MM1 net27 B M0_S_M1_D nch W=1u L=600n m=1 trise=0 flg_local_she=-1
MM0 Y C net27 nch W=1u L=600n m=1 trise=0 flg_local_she=-1
RR0 VDD Y $[resmod] $W=600n $L=88.8u m=1 trise=0 ncorners=10 flg_local_she=-1
.ENDS

************************************************************************
* auCdl Netlist:
*
* Library Name:  tft3d_sc_t5
* Top Cell Name: OAI211_X2RL_T5
* View Name:     schematic
* Netlisted on:  Mar  3 13:38:08 2026
************************************************************************

*.EQUATION
*.SCALE METER
*.MEGA
.PARAM

************************************************************************
* Library Name: tft3d_sc_t5
* Cell Name:    OAI211_X2RL_T5
* View Name:    schematic
************************************************************************

.SUBCKT OAI211_X2RL_T5 A1 A2 B C VDD VSS Y
*.PININFO A1:I A2:I B:I C:I Y:O VDD:B VSS:B
MM3 M0_S_M1_D A2 VSS nch W=1u L=600n m=1 trise=0 flg_local_she=-1
MM2 M0_S_M1_D A1 VSS nch W=1u L=600n m=1 trise=0 flg_local_she=-1
MM1 net27 B M0_S_M1_D nch W=1u L=600n m=1 trise=0 flg_local_she=-1
MM0 Y C net27 nch W=1u L=600n m=1 trise=0 flg_local_she=-1
RR0 VDD Y $[resmod] $W=600n $L=48.5u m=1 trise=0 ncorners=8 flg_local_she=-1
.ENDS

************************************************************************
* auCdl Netlist:
*
* Library Name:  tft3d_sc_t5
* Top Cell Name: OAI211_X4RL_T5
* View Name:     schematic
* Netlisted on:  Mar  3 13:38:13 2026
************************************************************************

*.EQUATION
*.SCALE METER
*.MEGA
.PARAM

************************************************************************
* Library Name: tft3d_sc_t5
* Cell Name:    OAI211_X4RL_T5
* View Name:    schematic
************************************************************************

.SUBCKT OAI211_X4RL_T5 A1 A2 B C VDD VSS Y
*.PININFO A1:I A2:I B:I C:I Y:O VDD:B VSS:B
MM3 M0_S_M1_D A2 VSS nch W=2u L=600n m=1 trise=0 flg_local_she=-1
MM2 M0_S_M1_D A1 VSS nch W=2u L=600n m=1 trise=0 flg_local_she=-1
MM1 net27 B M0_S_M1_D nch W=2u L=600n m=1 trise=0 flg_local_she=-1
MM0 Y C net27 nch W=2u L=600n m=1 trise=0 flg_local_she=-1
RR0 VDD Y $[resmod] $W=600n $L=24.2u m=1 trise=0 ncorners=4 flg_local_she=-1
.ENDS

************************************************************************
* auCdl Netlist:
*
* Library Name:  tft3d_sc_t5
* Top Cell Name: OAI21_X1RL_T5
* View Name:     schematic
* Netlisted on:  Mar  3 13:38:23 2026
************************************************************************

*.EQUATION
*.SCALE METER
*.MEGA
.PARAM

************************************************************************
* Library Name: tft3d_sc_t5
* Cell Name:    OAI21_X1RL_T5
* View Name:    schematic
************************************************************************

.SUBCKT OAI21_X1RL_T5 A1 A2 B VDD VSS Y
*.PININFO A1:I A2:I B:I Y:O VDD:B VSS:B
RR0 VDD Y $[resmod] $W=600n $L=88.8u m=1 trise=0 ncorners=10 flg_local_she=-1
MM2 M0_S_M1_D A2 VSS nch W=1u L=600n m=1 trise=0 flg_local_she=-1
MM0 Y B M0_S_M1_D nch W=1u L=600n m=1 trise=0 flg_local_she=-1
MM1 M0_S_M1_D A1 VSS nch W=1u L=600n m=1 trise=0 flg_local_she=-1
.ENDS

************************************************************************
* auCdl Netlist:
*
* Library Name:  tft3d_sc_t5
* Top Cell Name: OAI21_X2RL_T5
* View Name:     schematic
* Netlisted on:  Mar  3 13:38:15 2026
************************************************************************

*.EQUATION
*.SCALE METER
*.MEGA
.PARAM

************************************************************************
* Library Name: tft3d_sc_t5
* Cell Name:    OAI21_X2RL_T5
* View Name:    schematic
************************************************************************

.SUBCKT OAI21_X2RL_T5 A1 A2 B VDD VSS Y
*.PININFO A1:I A2:I B:I Y:O VDD:B VSS:B
RR0 VDD Y $[resmod] $W=600n $L=48.2u m=1 trise=0 ncorners=8 flg_local_she=-1
MM2 M0_S_M1_D A2 VSS nch W=1u L=600n m=1 trise=0 flg_local_she=-1
MM0 Y B M0_S_M1_D nch W=1u L=600n m=1 trise=0 flg_local_she=-1
MM1 M0_S_M1_D A1 VSS nch W=1u L=600n m=1 trise=0 flg_local_she=-1
.ENDS

************************************************************************
* auCdl Netlist:
*
* Library Name:  tft3d_sc_t5
* Top Cell Name: OAI21_X4RL_T5
* View Name:     schematic
* Netlisted on:  Mar  3 13:38:17 2026
************************************************************************

*.EQUATION
*.SCALE METER
*.MEGA
.PARAM

************************************************************************
* Library Name: tft3d_sc_t5
* Cell Name:    OAI21_X4RL_T5
* View Name:    schematic
************************************************************************

.SUBCKT OAI21_X4RL_T5 A1 A2 B VDD VSS Y
*.PININFO A1:I A2:I B:I Y:O VDD:B VSS:B
RR0 VDD Y $[resmod] $W=600n $L=24.2u m=1 trise=0 ncorners=4 flg_local_she=-1
MM2 M0_S_M1_D A2 VSS nch W=1u L=600n m=1 trise=0 flg_local_she=-1
MM0 Y B M0_S_M1_D nch W=1u L=600n m=1 trise=0 flg_local_she=-1
MM1 M0_S_M1_D A1 VSS nch W=1u L=600n m=1 trise=0 flg_local_she=-1
.ENDS

************************************************************************
* auCdl Netlist:
*
* Library Name:  tft3d_sc_t5
* Top Cell Name: OAI22_X1RL_T5
* View Name:     schematic
* Netlisted on:  Mar  3 13:38:22 2026
************************************************************************

*.EQUATION
*.SCALE METER
*.MEGA
.PARAM

************************************************************************
* Library Name: tft3d_sc_t5
* Cell Name:    OAI22_X1RL_T5
* View Name:    schematic
************************************************************************

.SUBCKT OAI22_X1RL_T5 A1 A2 B1 B2 VDD VSS Y
*.PININFO A1:I A2:I B1:I B2:I Y:O VDD:B VSS:B
RR0 VDD Y $[resmod] $W=600n $L=93.0u m=1 trise=0 ncorners=12 flg_local_she=-1
MM3 Y B2 net2 nch W=1u L=600n m=1 trise=0 flg_local_she=-1
MM2 net2 A2 VSS nch W=1u L=600n m=1 trise=0 flg_local_she=-1
MM1 net2 A1 VSS nch W=1u L=600n m=1 trise=0 flg_local_she=-1
MM0 Y B1 net2 nch W=1u L=600n m=1 trise=0 flg_local_she=-1
.ENDS

************************************************************************
* auCdl Netlist:
*
* Library Name:  tft3d_sc_t5
* Top Cell Name: OAI22_X2RL_T5
* View Name:     schematic
* Netlisted on:  Mar  3 13:38:24 2026
************************************************************************

*.EQUATION
*.SCALE METER
*.MEGA
.PARAM

************************************************************************
* Library Name: tft3d_sc_t5
* Cell Name:    OAI22_X2RL_T5
* View Name:    schematic
************************************************************************

.SUBCKT OAI22_X2RL_T5 A1 A2 B1 B2 VDD VSS Y
*.PININFO A1:I A2:I B1:I B2:I Y:O VDD:B VSS:B
RR0 VDD Y $[resmod] $W=600n $L=48.5u m=1 trise=0 ncorners=8 flg_local_she=-1
MM3 Y B2 net2 nch W=1u L=600n m=1 trise=0 flg_local_she=-1
MM2 net2 A2 VSS nch W=1u L=600n m=1 trise=0 flg_local_she=-1
MM1 net2 A1 VSS nch W=1u L=600n m=1 trise=0 flg_local_she=-1
MM0 Y B1 net2 nch W=1u L=600n m=1 trise=0 flg_local_she=-1
.ENDS

************************************************************************
* auCdl Netlist:
*
* Library Name:  tft3d_sc_t5
* Top Cell Name: OAI22_X4RL_T5
* View Name:     schematic
* Netlisted on:  Mar  3 13:38:31 2026
************************************************************************

*.EQUATION
*.SCALE METER
*.MEGA
.PARAM

************************************************************************
* Library Name: tft3d_sc_t5
* Cell Name:    OAI22_X4RL_T5
* View Name:    schematic
************************************************************************

.SUBCKT OAI22_X4RL_T5 A1 A2 B1 B2 VDD VSS Y
*.PININFO A1:I A2:I B1:I B2:I Y:O VDD:B VSS:B
RR0 VDD Y $[resmod] $W=600n $L=24.2u m=1 trise=0 ncorners=4 flg_local_she=-1
MM3 Y B2 net2 nch W=1u L=600n m=1 trise=0 flg_local_she=-1
MM2 net2 A2 VSS nch W=1u L=600n m=1 trise=0 flg_local_she=-1
MM1 net2 A1 VSS nch W=1u L=600n m=1 trise=0 flg_local_she=-1
MM0 Y B1 net2 nch W=1u L=600n m=1 trise=0 flg_local_she=-1
.ENDS

************************************************************************
* auCdl Netlist:
*
* Library Name:  tft3d_sc_t5
* Top Cell Name: OR2_X1RL_T5
* View Name:     schematic
* Netlisted on:  Mar  3 13:38:34 2026
************************************************************************

*.EQUATION
*.SCALE METER
*.MEGA
.PARAM

************************************************************************
* Library Name: tft3d_sc_t5
* Cell Name:    OR2_X1RL_T5
* View Name:    schematic
************************************************************************

.SUBCKT OR2_X1RL_T5 A1 A2 VDD VSS Y
*.PININFO A1:I A2:I Y:O VDD:B VSS:B
RR1 VDD Y $[resmod] $W=600n $L=90.6u m=1 trise=0 ncorners=10 flg_local_she=-1
RR0 VDD net6 $[resmod] $W=600n $L=92.7u m=1 trise=0 ncorners=12
+ flg_local_she=-1
MM2 Y net6 VSS nch W=1u L=600n m=1 trise=0 flg_local_she=-1
MM0 net6 A1 VSS nch W=1u L=600n m=1 trise=0 flg_local_she=-1
MM1 net6 A2 VSS nch W=1u L=600n m=1 trise=0 flg_local_she=-1
.ENDS

************************************************************************
* auCdl Netlist:
*
* Library Name:  tft3d_sc_t5
* Top Cell Name: OR2_X2RL_T5
* View Name:     schematic
* Netlisted on:  Mar  3 13:38:40 2026
************************************************************************

*.EQUATION
*.SCALE METER
*.MEGA
.PARAM

************************************************************************
* Library Name: tft3d_sc_t5
* Cell Name:    OR2_X2RL_T5
* View Name:    schematic
************************************************************************

.SUBCKT OR2_X2RL_T5 A1 A2 VDD VSS Y
*.PININFO A1:I A2:I Y:O VDD:B VSS:B
RR1 VDD Y $[resmod] $W=600n $L=48.5u m=1 trise=0 ncorners=8 flg_local_she=-1
RR0 VDD net6 $[resmod] $W=600n $L=91.0u m=1 trise=0 ncorners=10
+ flg_local_she=-1
MM2 Y net6 VSS nch W=1u L=600n m=1 trise=0 flg_local_she=-1
MM0 net6 A1 VSS nch W=1u L=600n m=1 trise=0 flg_local_she=-1
MM1 net6 A2 VSS nch W=1u L=600n m=1 trise=0 flg_local_she=-1
.ENDS

************************************************************************
* auCdl Netlist:
*
* Library Name:  tft3d_sc_t5
* Top Cell Name: OR2_X4RL_T5
* View Name:     schematic
* Netlisted on:  Mar  3 13:38:42 2026
************************************************************************

*.EQUATION
*.SCALE METER
*.MEGA
.PARAM

************************************************************************
* Library Name: tft3d_sc_t5
* Cell Name:    OR2_X4RL_T5
* View Name:    schematic
************************************************************************

.SUBCKT OR2_X4RL_T5 A1 A2 VDD VSS Y
*.PININFO A1:I A2:I Y:O VDD:B VSS:B
RR1 VDD Y $[resmod] $W=600n $L=24.1u m=1 trise=0 ncorners=4 flg_local_she=-1
RR0 VDD net6 $[resmod] $W=600n $L=91.0u m=1 trise=0 ncorners=10
+ flg_local_she=-1
MM2 Y net6 VSS nch W=1u L=600n m=1 trise=0 flg_local_she=-1
MM0 net6 A1 VSS nch W=1u L=600n m=1 trise=0 flg_local_she=-1
MM1 net6 A2 VSS nch W=1u L=600n m=1 trise=0 flg_local_she=-1
.ENDS

************************************************************************
* auCdl Netlist:
*
* Library Name:  tft3d_sc_t5
* Top Cell Name: OR3_X1RL_T5
* View Name:     schematic
* Netlisted on:  Mar  3 13:38:48 2026
************************************************************************

*.EQUATION
*.SCALE METER
*.MEGA
.PARAM

************************************************************************
* Library Name: tft3d_sc_t5
* Cell Name:    OR3_X1RL_T5
* View Name:    schematic
************************************************************************

.SUBCKT OR3_X1RL_T5 A1 A2 A3 VDD VSS Y
*.PININFO A1:I A2:I A3:I Y:O VDD:B VSS:B
RR1 VDD Y $[resmod] $W=600n $L=98.6u m=1 trise=0 ncorners=19 flg_local_she=-1
RR0 VDD net6 $[resmod] $W=600n $L=92.6u m=1 trise=0 ncorners=12
+ flg_local_she=-1
MM2 Y net6 VSS nch W=1u L=600n m=1 trise=0 flg_local_she=-1
MM3 net6 A2 VSS nch W=1u L=600n m=1 trise=0 flg_local_she=-1
MM0 net6 A1 VSS nch W=1u L=600n m=1 trise=0 flg_local_she=-1
MM1 net6 A3 VSS nch W=1u L=600n m=1 trise=0 flg_local_she=-1
.ENDS

************************************************************************
* auCdl Netlist:
*
* Library Name:  tft3d_sc_t5
* Top Cell Name: OR3_X2RL_T5
* View Name:     schematic
* Netlisted on:  Mar  3 13:38:49 2026
************************************************************************

*.EQUATION
*.SCALE METER
*.MEGA
.PARAM

************************************************************************
* Library Name: tft3d_sc_t5
* Cell Name:    OR3_X2RL_T5
* View Name:    schematic
************************************************************************

.SUBCKT OR3_X2RL_T5 A1 A2 A3 VDD VSS Y
*.PININFO A1:I A2:I A3:I Y:O VDD:B VSS:B
RR3 VDD Y $[resmod] $W=600n $L=50.6u m=1 trise=0 ncorners=10 flg_local_she=-1
RR0 VDD net6 $[resmod] $W=600n $L=92.7u m=1 trise=0 ncorners=12
+ flg_local_she=-1
MM2 Y net6 VSS nch W=1u L=600n m=1 trise=0 flg_local_she=-1
MM3 net6 A2 VSS nch W=1u L=600n m=1 trise=0 flg_local_she=-1
MM0 net6 A1 VSS nch W=1u L=600n m=1 trise=0 flg_local_she=-1
MM1 net6 A3 VSS nch W=1u L=600n m=1 trise=0 flg_local_she=-1
.ENDS

************************************************************************
* auCdl Netlist:
*
* Library Name:  tft3d_sc_t5
* Top Cell Name: OR3_X4RL_T5
* View Name:     schematic
* Netlisted on:  Mar  3 13:38:53 2026
************************************************************************

*.EQUATION
*.SCALE METER
*.MEGA
.PARAM

************************************************************************
* Library Name: tft3d_sc_t5
* Cell Name:    OR3_X4RL_T5
* View Name:    schematic
************************************************************************

.SUBCKT OR3_X4RL_T5 A1 A2 A3 VDD VSS Y
*.PININFO A1:I A2:I A3:I Y:O VDD:B VSS:B
RR4 VDD Y $[resmod] $W=600n $L=24.0u m=1 trise=0 ncorners=4 flg_local_she=-1
RR0 VDD net6 $[resmod] $W=600n $L=92.7u m=1 trise=0 ncorners=12
+ flg_local_she=-1
MM2 Y net6 VSS nch W=1u L=600n m=1 trise=0 flg_local_she=-1
MM3 net6 A2 VSS nch W=1u L=600n m=1 trise=0 flg_local_she=-1
MM0 net6 A1 VSS nch W=1u L=600n m=1 trise=0 flg_local_she=-1
MM1 net6 A3 VSS nch W=1u L=600n m=1 trise=0 flg_local_she=-1
.ENDS

************************************************************************
* auCdl Netlist:
*
* Library Name:  tft3d_sc_t5
* Top Cell Name: OR4_X1RL_T5
* View Name:     schematic
* Netlisted on:  Mar  3 13:38:59 2026
************************************************************************

*.EQUATION
*.SCALE METER
*.MEGA
.PARAM

************************************************************************
* Library Name: tft3d_sc_t5
* Cell Name:    OR4_X1RL_T5
* View Name:    schematic
************************************************************************

.SUBCKT OR4_X1RL_T5 A1 A2 A3 A4 VDD VSS Y
*.PININFO A1:I A2:I A3:I A4:I Y:O VDD:B VSS:B
RR2 VDD Y $[resmod] $W=600n $L=92.6u m=1 trise=0 ncorners=12 flg_local_she=-1
RR0 VDD net6 $[resmod] $W=600n $L=92.6u m=1 trise=0 ncorners=12
+ flg_local_she=-1
MM4 net6 A4 VSS nch W=1u L=600n m=1 trise=0 flg_local_she=-1
MM2 Y net6 VSS nch W=1u L=600n m=1 trise=0 flg_local_she=-1
MM3 net6 A2 VSS nch W=1u L=600n m=1 trise=0 flg_local_she=-1
MM0 net6 A1 VSS nch W=1u L=600n m=1 trise=0 flg_local_she=-1
MM1 net6 A3 VSS nch W=1u L=600n m=1 trise=0 flg_local_she=-1
.ENDS

************************************************************************
* auCdl Netlist:
*
* Library Name:  tft3d_sc_t5
* Top Cell Name: OR4_X2RL_T5
* View Name:     schematic
* Netlisted on:  Mar  3 13:39:01 2026
************************************************************************

*.EQUATION
*.SCALE METER
*.MEGA
.PARAM

************************************************************************
* Library Name: tft3d_sc_t5
* Cell Name:    OR4_X2RL_T5
* View Name:    schematic
************************************************************************

.SUBCKT OR4_X2RL_T5 A1 A2 A3 A4 VDD VSS Y
*.PININFO A1:I A2:I A3:I A4:I Y:O VDD:B VSS:B
RR2 VDD Y $[resmod] $W=600n $L=52.6u m=1 trise=0 ncorners=12 flg_local_she=-1
RR0 VDD net6 $[resmod] $W=600n $L=92.7u m=1 trise=0 ncorners=12
+ flg_local_she=-1
MM4 net6 A4 VSS nch W=1u L=600n m=1 trise=0 flg_local_she=-1
MM2 Y net6 VSS nch W=1u L=600n m=1 trise=0 flg_local_she=-1
MM3 net6 A2 VSS nch W=1u L=600n m=1 trise=0 flg_local_she=-1
MM0 net6 A1 VSS nch W=1u L=600n m=1 trise=0 flg_local_she=-1
MM1 net6 A3 VSS nch W=1u L=600n m=1 trise=0 flg_local_she=-1
.ENDS

************************************************************************
* auCdl Netlist:
*
* Library Name:  tft3d_sc_t5
* Top Cell Name: OR4_X4RL_T5
* View Name:     schematic
* Netlisted on:  Mar  3 13:39:03 2026
************************************************************************

*.EQUATION
*.SCALE METER
*.MEGA
.PARAM

************************************************************************
* Library Name: tft3d_sc_t5
* Cell Name:    OR4_X4RL_T5
* View Name:    schematic
************************************************************************

.SUBCKT OR4_X4RL_T5 A1 A2 A3 A4 VDD VSS Y
*.PININFO A1:I A2:I A3:I A4:I Y:O VDD:B VSS:B
RR2 VDD Y $[resmod] $W=600n $L=24.0u m=1 trise=0 ncorners=4 flg_local_she=-1
RR0 VDD net6 $[resmod] $W=600n $L=92.7u m=1 trise=0 ncorners=12
+ flg_local_she=-1
MM4 net6 A4 VSS nch W=1u L=600n m=1 trise=0 flg_local_she=-1
MM2 Y net6 VSS nch W=1u L=600n m=1 trise=0 flg_local_she=-1
MM3 net6 A2 VSS nch W=1u L=600n m=1 trise=0 flg_local_she=-1
MM0 net6 A1 VSS nch W=1u L=600n m=1 trise=0 flg_local_she=-1
MM1 net6 A3 VSS nch W=1u L=600n m=1 trise=0 flg_local_she=-1
.ENDS

************************************************************************
* auCdl Netlist:
*
* Library Name:  tft3d_sc_t5
* Top Cell Name: TIEHI_T5
* View Name:     schematic
* Netlisted on:  Mar  3 13:39:07 2026
************************************************************************

*.EQUATION
*.SCALE METER
*.MEGA
.PARAM

************************************************************************
* Library Name: tft3d_sc_t5
* Cell Name:    TIEHI_T5
* View Name:    schematic
************************************************************************

.SUBCKT TIEHI_T5 VDD VSS Y
*.PININFO Y:O VDD:B VSS:B
RR0 VDD Y $[resmod] $W=1.6u $L=5.2u m=1 trise=0 ncorners=0 flg_local_she=-1
.ENDS

************************************************************************
* auCdl Netlist:
*
* Library Name:  tft3d_sc_t5
* Top Cell Name: TIELO_T5
* View Name:     schematic
* Netlisted on:  Mar  3 13:39:10 2026
************************************************************************

*.EQUATION
*.SCALE METER
*.MEGA
.PARAM

************************************************************************
* Library Name: tft3d_sc_t5
* Cell Name:    TIELO_T5
* View Name:    schematic
************************************************************************

.SUBCKT TIELO_T5 VDD VSS Y
*.PININFO Y:O VDD:B VSS:B
RR0 Y VSS $[resmod] $W=1.6u $L=5.2u m=1 trise=0 ncorners=0 flg_local_she=-1
.ENDS

************************************************************************
* auCdl Netlist:
*
* Library Name:  tft3d_sc_t5
* Top Cell Name: XNOR2_X1RL_T5
* View Name:     schematic
* Netlisted on:  Mar  3 13:39:24 2026
************************************************************************

*.EQUATION
*.SCALE METER
*.MEGA
.PARAM

************************************************************************
* Library Name: tft3d_sc_t5
* Cell Name:    XNOR2_X1RL_T5
* View Name:    schematic
************************************************************************

.SUBCKT XNOR2_X1RL_T5 A1 A2 VDD VSS Y
*.PININFO A1:I A2:I Y:O VDD:B VSS:B
MM5 net16 A2 VSS nch W=1u L=600n m=1 trise=0 flg_local_she=-1
MM4 Y A1bar net16 nch W=1u L=600n m=1 trise=0 flg_local_she=-1
MM3 net17 A1 VSS nch W=1u L=600n m=1 trise=0 flg_local_she=-1
MM2 Y A2bar net17 nch W=1u L=600n m=1 trise=0 flg_local_she=-1
MM1 A2bar A2 VSS nch W=1u L=600n m=1 trise=0 flg_local_she=-1
MM0 A1bar A1 VSS nch W=1u L=600n m=1 trise=0 flg_local_she=-1
RR5 VDD A1bar $[resmod] $W=600n $L=89.0u m=1 trise=0 ncorners=8
+ flg_local_she=-1
RR4 VDD Y $[resmod] $W=600n $L=89.0u m=1 trise=0 ncorners=8 flg_local_she=-1
RR3 VDD A2bar $[resmod] $W=600n $L=92.7u m=1 trise=0 ncorners=10
+ flg_local_she=-1
.ENDS

************************************************************************
* auCdl Netlist:
*
* Library Name:  tft3d_sc_t5
* Top Cell Name: XNOR2_X2RL_T5
* View Name:     schematic
* Netlisted on:  Mar  3 13:39:34 2026
************************************************************************

*.EQUATION
*.SCALE METER
*.MEGA
.PARAM

************************************************************************
* Library Name: tft3d_sc_t5
* Cell Name:    XNOR2_X2RL_T5
* View Name:    schematic
************************************************************************

.SUBCKT XNOR2_X2RL_T5 A1 A2 VDD VSS Y
*.PININFO A1:I A2:I Y:O VDD:B VSS:B
MM0 A1N A1 VSS nch W=1u L=600n m=1 trise=0 flg_local_she=-1
MM1 A2N A2 VSS nch W=1u L=600n m=1 trise=0 flg_local_she=-1
MM2 Y A2N net1 nch W=1u L=600n m=1 trise=0 flg_local_she=-1
MM3 net1 A1 VSS nch W=1u L=600n m=1 trise=0 flg_local_she=-1
MM4 Y A1N net2 nch W=1u L=600n m=1 trise=0 flg_local_she=-1
MM5 net2 A2 VSS nch W=1u L=600n m=1 trise=0 flg_local_she=-1
RR0 VDD A1N $[resmod] $W=600n $L=89.0u m=1 trise=0 ncorners=8 flg_local_she=-1
RR1 VDD A2N $[resmod] $W=600n $L=89.1u m=1 trise=0 ncorners=13 flg_local_she=-1
RR2 VDD Y $[resmod] $W=600n $L=48.8u m=1 trise=0 ncorners=8 flg_local_she=-1
.ENDS

************************************************************************
* auCdl Netlist:
*
* Library Name:  tft3d_sc_t5
* Top Cell Name: XNOR2_X4RL_T5
* View Name:     schematic
* Netlisted on:  Mar  3 13:39:12 2026
************************************************************************

*.EQUATION
*.SCALE METER
*.MEGA
.PARAM

************************************************************************
* Library Name: tft3d_sc_t5
* Cell Name:    XNOR2_X4RL_T5
* View Name:    schematic
************************************************************************

.SUBCKT XNOR2_X4RL_T5 A1 A2 VDD VSS Y
*.PININFO A1:I A2:I Y:O VDD:B VSS:B
MM5 net16 A2 VSS nch W=2u L=600n m=1 trise=0 flg_local_she=-1
MM4 Y A1N net16 nch W=2u L=600n m=1 trise=0 flg_local_she=-1
MM3 net15 A1 VSS nch W=2u L=600n m=1 trise=0 flg_local_she=-1
MM2 Y A2N net15 nch W=2u L=600n m=1 trise=0 flg_local_she=-1
MM1 A2N A2 VSS nch W=1u L=600n m=1 trise=0 flg_local_she=-1
MM0 A1N A1 VSS nch W=1u L=600n m=1 trise=0 flg_local_she=-1
RR2 VDD Y $[resmod] $W=600n $L=27.8u m=1 trise=0 ncorners=8 flg_local_she=-1
RR1 VDD A2N $[resmod] $W=600n $L=89.0u m=1 trise=0 ncorners=13 flg_local_she=-1
RR0 VDD A1N $[resmod] $W=600n $L=89.0u m=1 trise=0 ncorners=8 flg_local_she=-1
.ENDS

************************************************************************
* auCdl Netlist:
*
* Library Name:  tft3d_sc_t5
* Top Cell Name: XOR2_X1RL_T5
* View Name:     schematic
* Netlisted on:  Mar  3 13:39:23 2026
************************************************************************

*.EQUATION
*.SCALE METER
*.MEGA
.PARAM

************************************************************************
* Library Name: tft3d_sc_t5
* Cell Name:    XOR2_X1RL_T5
* View Name:    schematic
************************************************************************

.SUBCKT XOR2_X1RL_T5 A1 A2 VDD VSS Y
*.PININFO A1:I A2:I Y:O VDD:B VSS:B
RR2 VDD Y $[resmod] $W=600n $L=89.0u m=1 trise=0 ncorners=8 flg_local_she=-1
RR1 VDD A2N $[resmod] $W=600n $L=90.6u m=1 trise=0 ncorners=10 flg_local_she=-1
RR0 VDD A1N $[resmod] $W=600n $L=85.4u m=1 trise=0 ncorners=6 flg_local_she=-1
MM2 Y A2 net2 nch W=1u L=600n m=1 trise=0 flg_local_she=-1
MM4 Y A2N net1 nch W=1u L=600n m=1 trise=0 flg_local_she=-1
MM3 net2 A1 VSS nch W=1u L=600n m=1 trise=0 flg_local_she=-1
MM5 net1 A1N VSS nch W=1u L=600n m=1 trise=0 flg_local_she=-1
MM1 A2N A2 VSS nch W=1u L=600n m=1 trise=0 flg_local_she=-1
MM0 A1N A1 VSS nch W=1u L=600n m=1 trise=0 flg_local_she=-1
.ENDS

************************************************************************
* auCdl Netlist:
*
* Library Name:  tft3d_sc_t5
* Top Cell Name: XOR2_X2RL_T5
* View Name:     schematic
* Netlisted on:  Mar  3 13:39:16 2026
************************************************************************

*.EQUATION
*.SCALE METER
*.MEGA
.PARAM

************************************************************************
* Library Name: tft3d_sc_t5
* Cell Name:    XOR2_X2RL_T5
* View Name:    schematic
************************************************************************

.SUBCKT XOR2_X2RL_T5 A1 A2 VDD VSS Y
*.PININFO A1:I A2:I Y:O VDD:B VSS:B
RR4 VDD A2N $[resmod] $W=600n $L=90.6u m=1 trise=0 ncorners=10 flg_local_she=-1
RR3 VDD A1N $[resmod] $W=600n $L=85.4u m=1 trise=0 ncorners=6 flg_local_she=-1
RR2 VDD Y $[resmod] $W=600n $L=46.0u m=1 trise=0 ncorners=5 flg_local_she=-1
MM0 A1N A1 VSS nch W=1u L=600n m=1 trise=0 flg_local_she=-1
MM1 A2N A2 VSS nch W=1u L=600n m=1 trise=0 flg_local_she=-1
MM5 net2 A1N VSS nch W=1u L=600n m=1 trise=0 flg_local_she=-1
MM3 net1 A1 VSS nch W=1u L=600n m=1 trise=0 flg_local_she=-1
MM4 Y A2N net2 nch W=1u L=600n m=1 trise=0 flg_local_she=-1
MM2 Y A2 net1 nch W=1u L=600n m=1 trise=0 flg_local_she=-1
.ENDS

************************************************************************
* auCdl Netlist:
*
* Library Name:  tft3d_sc_t5
* Top Cell Name: XOR2_X4RL_T5
* View Name:     schematic
* Netlisted on:  Mar  3 13:39:20 2026
************************************************************************

*.EQUATION
*.SCALE METER
*.MEGA
.PARAM

************************************************************************
* Library Name: tft3d_sc_t5
* Cell Name:    XOR2_X4RL_T5
* View Name:    schematic
************************************************************************

.SUBCKT XOR2_X4RL_T5 A1 A2 VDD VSS Y
*.PININFO A1:I A2:I Y:O VDD:B VSS:B
RR2 VDD Y $[resmod] $W=600n $L=23.5u m=1 trise=0 ncorners=6 flg_local_she=-1
RR0 VDD A1N $[resmod] $W=600n $L=85.4u m=1 trise=0 ncorners=6 flg_local_she=-1
RR1 VDD A2N $[resmod] $W=600n $L=90.6u m=1 trise=0 ncorners=10 flg_local_she=-1
MM2 Y A2 net1 nch W=2u L=600n m=1 trise=0 flg_local_she=-1
MM4 Y A2N net2 nch W=2u L=600n m=1 trise=0 flg_local_she=-1
MM3 net1 A1 VSS nch W=2u L=600n m=1 trise=0 flg_local_she=-1
MM5 net2 A1N VSS nch W=2u L=600n m=1 trise=0 flg_local_she=-1
MM1 A2N A2 VSS nch W=1u L=600n m=1 trise=0 flg_local_she=-1
MM0 A1N A1 VSS nch W=1u L=600n m=1 trise=0 flg_local_she=-1
.ENDS
