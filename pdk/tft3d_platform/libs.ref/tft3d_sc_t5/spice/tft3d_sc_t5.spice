* Basic simulator-clean standard-cell SPICE views for the neutral 3D_TFT platform.
* Device models are supplied by libs.tech/ngspice/tft3d_platform_primitives.spice.
* These models are intended for flow bring-up and functional circuit checks.

.SUBCKT AND2_X1RL_T5 A1 A2 VDD VSS Y
RR1 VDD Y 148000
RR0 VDD YN 156333
MM2 Y YN VSS VSS nch W=1u L=600n M=1
MM0 YN A1 net1 VSS nch W=1u L=600n M=1
MM1 net1 A2 VSS VSS nch W=1u L=600n M=1
.ENDS
.SUBCKT AND2_X2RL_T5 A1 A2 VDD VSS Y
RR1 VDD Y 74166.7
RR0 VDD YN 156333
MM2 Y YN VSS VSS nch W=1u L=600n M=1
MM0 YN A1 net1 VSS nch W=1u L=600n M=1
MM1 net1 A2 VSS VSS nch W=1u L=600n M=1
.ENDS
.SUBCKT AND2_X4RL_T5 A1 A2 VDD VSS Y
RR1 VDD Y 40500
RR0 VDD YN 156333
MM2 Y YN VSS VSS nch W=1u L=600n M=1
MM0 YN A1 net1 VSS nch W=1u L=600n M=1
MM1 net1 A2 VSS VSS nch W=1u L=600n M=1
.ENDS
.SUBCKT AND3_X1RL_T5 A1 A2 A3 VDD VSS Y
RR3 VDD Y 154333
RR0 VDD net17 156333
MM3 net09 A3 VSS VSS nch W=1u L=600n M=1
MM2 Y net17 VSS VSS nch W=1u L=600n M=1
MM0 net17 A1 M0_S_M1_D VSS nch W=1u L=600n M=1
MM1 M0_S_M1_D A2 net09 VSS nch W=1u L=600n M=1
.ENDS
.SUBCKT AND3_X2RL_T5 A1 A2 A3 VDD VSS Y
RR2 VDD YN 156333
RR1 VDD Y 87666.7
MM3 Y YN VSS VSS nch W=1u L=600n M=1
MM0 YN A1 net1 VSS nch W=1u L=600n M=1
MM1 net1 A2 net2 VSS nch W=1u L=600n M=1
MM2 net2 A3 VSS VSS nch W=1u L=600n M=1
.ENDS
.SUBCKT AND3_X4RL_T5 A1 A2 A3 VDD VSS Y
RR0 VDD YN 156333
RR1 VDD Y 40166.7
MM3 Y YN VSS VSS nch W=1u L=600n M=1
MM0 YN A1 net1 VSS nch W=1u L=600n M=1
MM1 net1 A2 net2 VSS nch W=1u L=600n M=1
MM2 net2 A3 VSS VSS nch W=1u L=600n M=1
.ENDS
.SUBCKT AND4_X1RL_T5 A1 A2 A3 A4 VDD VSS Y
RR3 VDD Y 154333
RR0 VDD net17 156667
MM4 net010 A4 VSS VSS nch W=1u L=600n M=1
MM3 net09 A3 net010 VSS nch W=1u L=600n M=1
MM2 Y net17 VSS VSS nch W=1u L=600n M=1
MM0 net17 A1 M0_S_M1_D VSS nch W=1u L=600n M=1
MM1 M0_S_M1_D A2 net09 VSS nch W=1u L=600n M=1
.ENDS
.SUBCKT AND4_X2RL_T5 A1 A2 A3 A4 VDD VSS Y
RR1 VDD Y 81666.7
RR0 VDD YN 156667
MM4 Y YN VSS VSS nch W=1u L=600n M=1
MM0 YN A1 net1 VSS nch W=1u L=600n M=1
MM1 net1 A2 net2 VSS nch W=1u L=600n M=1
MM2 net2 A3 net3 VSS nch W=1u L=600n M=1
MM3 net3 A4 VSS VSS nch W=1u L=600n M=1
.ENDS
.SUBCKT AND4_X4RL_T5 A1 A2 A3 A4 VDD VSS Y
RR0 VDD YN 156667
RR1 VDD Y 46666.7
MM4 Y YN VSS VSS nch W=1u L=600n M=1
MM0 YN A1 net1 VSS nch W=1u L=600n M=1
MM1 net1 A2 net2 VSS nch W=1u L=600n M=1
MM2 net2 A3 net3 VSS nch W=1u L=600n M=1
MM3 net3 A4 VSS VSS nch W=1u L=600n M=1
.ENDS
.SUBCKT AOI211_X1RL_T5 A1 A2 B C VDD VSS Y
RR0 VDD Y 154500
MM3 Y C VSS VSS nch W=1u L=600n M=1
MM0 Y A1 M0_S_M1_D VSS nch W=1u L=600n M=1
MM1 M0_S_M1_D A2 VSS VSS nch W=1u L=600n M=1
MM2 Y B VSS VSS nch W=1u L=600n M=1
.ENDS
.SUBCKT AOI211_X2RL_T5 A1 A2 B C VDD VSS Y
RR0 VDD Y 80833.3
MM3 Y C VSS VSS nch W=1u L=600n M=1
MM0 Y A1 M0_S_M1_D VSS nch W=1u L=600n M=1
MM1 M0_S_M1_D A2 VSS VSS nch W=1u L=600n M=1
MM2 Y B VSS VSS nch W=1u L=600n M=1
.ENDS
.SUBCKT AOI211_X4RL_T5 A1 A2 B C VDD VSS Y
RR0 VDD Y 40166.7
MM3 Y C VSS VSS nch W=1u L=600n M=1
MM0 Y A1 M0_S_M1_D VSS nch W=1u L=600n M=1
MM1 M0_S_M1_D A2 VSS VSS nch W=1u L=600n M=1
MM2 Y B VSS VSS nch W=1u L=600n M=1
.ENDS
.SUBCKT AOI21_X1RL_T5 A1 A2 B VDD VSS Y
RR0 VDD Y 154500
MM2 Y B VSS VSS nch W=1u L=600n M=1
MM0 Y A1 M0_S_M1_D VSS nch W=1u L=600n M=1
MM1 M0_S_M1_D A2 VSS VSS nch W=1u L=600n M=1
.ENDS
.SUBCKT AOI21_X2RL_T5 A1 A2 B VDD VSS Y
RR0 VDD Y 86833.3
MM2 Y B VSS VSS nch W=1u L=600n M=1
MM0 Y A1 M0_S_M1_D VSS nch W=1u L=600n M=1
MM1 M0_S_M1_D A2 VSS VSS nch W=1u L=600n M=1
.ENDS
.SUBCKT AOI21_X4RL_T5 A1 A2 B VDD VSS Y
RR0 VDD Y 46666.7
MM2 Y B VSS VSS nch W=1u L=600n M=1
MM0 Y A1 M0_S_M1_D VSS nch W=1u L=600n M=1
MM1 M0_S_M1_D A2 VSS VSS nch W=1u L=600n M=1
.ENDS
.SUBCKT AOI22_X1RL_T5 A1 A2 B1 B2 VDD VSS Y
RR0 VDD Y 154500
MM3 net20 B2 VSS VSS nch W=1u L=600n M=1
MM0 Y A1 M0_S_M1_D VSS nch W=1u L=600n M=1
MM1 M0_S_M1_D A2 VSS VSS nch W=1u L=600n M=1
MM2 Y B1 net20 VSS nch W=1u L=600n M=1
.ENDS
.SUBCKT AOI22_X2RL_T5 A1 A2 B1 B2 VDD VSS Y
RR0 VDD Y 80833.3
MM3 net20 B2 VSS VSS nch W=1u L=600n M=1
MM0 Y A1 M0_S_M1_D VSS nch W=1u L=600n M=1
MM1 M0_S_M1_D A2 VSS VSS nch W=1u L=600n M=1
MM2 Y B1 net20 VSS nch W=1u L=600n M=1
.ENDS
.SUBCKT AOI22_X4RL_T5 A1 A2 B1 B2 VDD VSS Y
RR0 VDD Y 40166.7
MM3 net20 B2 VSS VSS nch W=2u L=600n M=1
MM0 Y A1 M0_S_M1_D VSS nch W=2u L=600n M=1
MM1 M0_S_M1_D A2 VSS VSS nch W=2u L=600n M=1
MM2 Y B1 net20 VSS nch W=2u L=600n M=1
.ENDS
.SUBCKT BUF_X1PC_T5 A VDD VSS Y
RR1 VDD ANN 151000
RR0 VDD AN 154500
MM3 Y AN VSS VSS nch W=1u L=600n M=1
MM2 VDD ANN Y VSS nch W=1u L=600n M=1
MM1 ANN AN VSS VSS nch W=1u L=600n M=1
MM0 AN A VSS VSS nch W=1u L=600n M=1
.ENDS
.SUBCKT BUF_X1RL_T5 A VDD VSS Y
RR1 VDD Y 160667
RR0 VDD ABAR 164333
MM1 Y ABAR VSS VSS nch W=1u L=600n M=1
MM0 ABAR A VSS VSS nch W=1u L=600n M=1
.ENDS
.SUBCKT BUF_X2PC_T5 A VDD VSS Y
RR1 VDD ANN 80333.3
RR0 VDD AN 154500
MM3 Y AN VSS VSS nch W=2u L=600n M=1
MM2 VDD ANN Y VSS nch W=2u L=600n M=1
MM1 ANN AN VSS VSS nch W=2u L=600n M=1
MM0 AN A VSS VSS nch W=1u L=600n M=1
.ENDS
.SUBCKT BUF_X2RL_T5 A VDD VSS Y
RR1 VDD Y 84333.3
RR0 VDD AN 164333
MM0 AN A VSS VSS nch W=1u L=600n M=1
MM1 Y AN VSS VSS nch W=1u L=600n M=1
.ENDS
.SUBCKT BUF_X4PC_T5 A VDD VSS Y
RR1 VDD ANN 46666.7
RR0 VDD AN 152167
MM3 Y AN VSS VSS nch W=4u L=600n M=1
MM2 VDD ANN Y VSS nch W=4u L=600n M=1
MM1 ANN AN VSS VSS nch W=4u L=600n M=1
MM0 AN A VSS VSS nch W=1u L=600n M=1
.ENDS
.SUBCKT BUF_X4RL_T5 A VDD VSS Y
RR1 VDD Y 49666.7
RR0 VDD ABAR 164333
MM1 Y ABAR VSS VSS nch W=2u L=600n M=1
MM0 ABAR A VSS VSS nch W=1u L=600n M=1
.ENDS
.SUBCKT CLKBUF_F2X2PC_T5 Y VDD VSS A
RR1 VDD ANN 21666.7
RR0 VDD AN 21666.7
MM3 Y AN VSS VSS nch W=2u L=600n M=1
MM2 VDD ANN Y VSS nch W=2u L=600n M=1
MM1 ANN AN VSS VSS nch W=1u L=600n M=1
MM0 AN A VSS VSS nch W=4u L=600n M=1
.ENDS
.SUBCKT CLKBUF_F4X2PC_T5 Y VDD VSS A
RR1 VDD ANN 5000
RR2 VDD AN 7166.67
MM3 Y AN VSS VSS nch W=2u L=600n M=1
MM2 VDD ANN Y VSS nch W=4u L=600n M=1
MM1 ANN AN VSS VSS nch W=1u L=600n M=1
MM0 AN A VSS VSS nch W=4u L=600n M=1
.ENDS
.SUBCKT CLKBUF_X2PC_T5 Y VDD VSS A
RR1 VDD ANN 38333.3
RR0 VDD AN 38333.3
MM3 Y AN VSS VSS nch W=2u L=600n M=1
MM2 VDD ANN Y VSS nch W=2u L=600n M=1
MM1 ANN AN VSS VSS nch W=1u L=600n M=1
MM0 AN A VSS VSS nch W=1u L=600n M=1
.ENDS
.SUBCKT CLKBUF_X8PC_T5 Y VDD VSS A
RR3 VDD AN 43666.7
RR1 VDD ANN 23666.7
MM3 Y AN VSS VSS nch W=8u L=600n M=1
MM2 VDD ANN Y VSS nch W=8u L=600n M=1
MM1 ANN AN VSS VSS nch W=2u L=600n M=1
MM0 AN A VSS VSS nch W=2u L=600n M=1
.ENDS
.SUBCKT DFFC_F2X1PC_T5 Q QN VDD VSS CLK CLR D
RR2 VDD MN 153667
RR3 VDD M 164333
RR4 VDD SN 84333.3
RR5 VDD S 84333.3
RR0 VDD CLKN 40166.7
RR1 VDD CLKNN 40166.7
MM2 D CLKN D_ VSS nch W=1u L=600n M=1
MM3 D_ CLKNN M VSS nch W=1u L=600n M=1
MM4 MN D_ VSS VSS nch W=1u L=600n M=1
MM5 M MN VSS VSS nch W=1u L=600n M=1
MM6 MN CLKNN MN_ VSS nch W=1u L=600n M=1
MM7 MN_ CLKN S VSS nch W=1u L=600n M=1
MM8 SN MN_ VSS VSS nch W=1u L=600n M=1
MM9 S SN VSS VSS nch W=1u L=600n M=1
MM0 CLKN CLK VSS VSS nch W=1u L=600n M=1
MM1 CLKNN CLKN VSS VSS nch W=1u L=600n M=1
MM10 QN SN VSS VSS nch W=1u L=600n M=1
MM11 Q S VSS VSS nch W=1u L=600n M=1
MM12 VDD S QN VSS nch W=1u L=600n M=1
MM13 VDD SN Q VSS nch W=1u L=600n M=1
MM14 M CLR VSS VSS nch W=1u L=600n M=1
MM15 SN CLR VSS VSS nch W=1u L=600n M=1
.ENDS
.SUBCKT DFFC_F4X1PC_T5 Q QN VDD VSS CLK CLR D
RR7 VDD M 80833.3
RR6 VDD MN 80333.3
RR8 VDD CLKN 16833.3
RR9 VDD CLKNN 16833.3
RR5 VDD S 40166.7
RR4 VDD SN 40166.7
MM15 SN CLR VSS VSS nch W=1u L=600n M=1
MM14 M CLR VSS VSS nch W=1u L=600n M=1
MM13 VDD SN Q VSS nch W=1u L=600n M=1
MM12 VDD S QN VSS nch W=1u L=600n M=1
MM11 Q S VSS VSS nch W=1u L=600n M=1
MM10 QN SN VSS VSS nch W=1u L=600n M=1
MM1 CLKNN CLKN VSS VSS nch W=1u L=600n M=1
MM0 CLKN CLK VSS VSS nch W=1u L=600n M=1
MM9 S SN VSS VSS nch W=1u L=600n M=1
MM8 SN MN_ VSS VSS nch W=1u L=600n M=1
MM7 MN_ CLKN S VSS nch W=1u L=600n M=1
MM6 MN CLKNN MN_ VSS nch W=1u L=600n M=1
MM5 M MN VSS VSS nch W=1u L=600n M=1
MM4 MN D_ VSS VSS nch W=1u L=600n M=1
MM3 D_ CLKNN M VSS nch W=1u L=600n M=1
MM2 D CLKN D_ VSS nch W=1u L=600n M=1
.ENDS
.SUBCKT DFFC_X1PC_T5 Q QN VDD VSS CLK CLR D
RR1 VDD CLKNN 160667
RR0 VDD CLKN 151000
RR5 VDD S 154667
RR4 VDD SN 164333
RR3 VDD M 164333
RR2 VDD MN 154333
MM15 SN CLR VSS VSS nch W=1u L=600n M=1
MM14 M CLR VSS VSS nch W=1u L=600n M=1
MM13 VDD SN Q VSS nch W=1u L=600n M=1
MM12 VDD S QN VSS nch W=1u L=600n M=1
MM11 Q S VSS VSS nch W=1u L=600n M=1
MM10 QN SN VSS VSS nch W=1u L=600n M=1
MM1 CLKNN CLKN VSS VSS nch W=1u L=600n M=1
MM0 CLKN CLK VSS VSS nch W=1u L=600n M=1
MM9 S SN VSS VSS nch W=1u L=600n M=1
MM8 SN MN_ VSS VSS nch W=1u L=600n M=1
MM7 MN_ CLKN S VSS nch W=1u L=600n M=1
MM6 MN CLKNN MN_ VSS nch W=1u L=600n M=1
MM5 M MN VSS VSS nch W=1u L=600n M=1
MM4 MN D_ VSS VSS nch W=1u L=600n M=1
MM3 D_ CLKNN M VSS nch W=1u L=600n M=1
MM2 D CLKN D_ VSS nch W=1u L=600n M=1
.ENDS
.SUBCKT DFF_X1PC_T5 Q QN VDD VSS CLK D
RR1 VDD CLKNN 160667
RR0 VDD CLKN 151000
RR5 VDD S 154667
RR4 VDD SN 164333
RR3 VDD M 164333
RR2 VDD MN 154333
MM13 VDD SN Q VSS nch W=1u L=600n M=1
MM12 VDD S QN VSS nch W=1u L=600n M=1
MM11 Q S VSS VSS nch W=1u L=600n M=1
MM10 QN SN VSS VSS nch W=1u L=600n M=1
MM1 CLKNN CLKN VSS VSS nch W=1u L=600n M=1
MM0 CLKN CLK VSS VSS nch W=1u L=600n M=1
MM9 S SN VSS VSS nch W=1u L=600n M=1
MM8 SN MN_ VSS VSS nch W=1u L=600n M=1
MM7 MN_ CLKN S VSS nch W=1u L=600n M=1
MM6 MN CLKNN MN_ VSS nch W=1u L=600n M=1
MM5 M MN VSS VSS nch W=1u L=600n M=1
MM4 MN D_ VSS VSS nch W=1u L=600n M=1
MM3 D_ CLKNN M VSS nch W=1u L=600n M=1
MM2 D CLKN D_ VSS nch W=1u L=600n M=1
.ENDS
.SUBCKT DLY1_X1PC_T5 Y VDD VSS A
RR1 VDD ANN 154500
RR0 VDD AN 152333
MM3 Y AN VSS VSS nch W=1u L=1.2u M=1
MM2 VDD ANN Y VSS nch W=1u L=1.2u M=1
MM1 ANN AN VSS VSS nch W=1u L=600n M=1
MM0 AN A VSS VSS nch W=1u L=1.2u M=1
.ENDS
.SUBCKT DLY1_X1RL_T5 Y VDD VSS A
RR0 VDD AN 49666.7
RR1 VDD Y 154500
MM0 AN A VSS VSS nch W=1u L=600n M=1
MM1 Y AN VSS VSS nch W=1u L=600n M=1
.ENDS
.SUBCKT DLY2_X1PC_T5 Y VDD VSS A
RR0 VDD AN 152333
RR1 VDD ANN 154333
MM0 AN A VSS VSS nch W=1u L=1.2u M=1
MM1 ANN AN VSS VSS nch W=1u L=600n M=1
MM2 VDD ANN Y VSS nch W=1u L=1.2u M=1
MM3 Y AN VSS VSS nch W=1u L=1.2u M=1
.ENDS
.SUBCKT DLY2_X1RL_T5 Y VDD VSS A
RR0 VDD AN 49666.7
RR1 VDD Y 154500
MM0 AN A VSS VSS nch W=1u L=600n M=1
MM1 Y AN VSS VSS nch W=1u L=600n M=1
.ENDS
.SUBCKT DLY4_X1PC_T5 A Y VDD VSS
RR1 VDD ANN 154500
RR0 VDD AN 152333
MM3 Y AN VSS VSS nch W=1u L=1.2u M=1
MM2 VDD ANN Y VSS nch W=1u L=1.2u M=1
MM1 ANN AN VSS VSS nch W=1u L=600n M=1
MM0 AN A VSS VSS nch W=1u L=1.2u M=1
.ENDS
.SUBCKT DLY4_X1RL_T5 Y VDD VSS A
RR1 VDD Y 148167
RR0 VDD AN 33500
MM1 Y AN VSS VSS nch W=1u L=600n M=1
MM0 AN A VSS VSS nch W=1u L=600n M=1
.ENDS
.SUBCKT FILLCAP1_T5 VDD VSS
.ENDS
.SUBCKT FILLCAP2_T5 VDD VSS
.ENDS
.SUBCKT FILLCAP4_T5 VDD VSS
.ENDS
.SUBCKT FILLCAP8_T5 VDD VSS
.ENDS
.SUBCKT HA_X1RL_T5 A B CO S VDD VSS
MM5 net23 A VSS VSS nch W=1u L=600n M=1
MM6 net23 B VSS VSS nch W=1u L=600n M=1
MM0 net28 B VSS VSS nch W=1u L=600n M=1
MM1 CO_BAR A net28 VSS nch W=1u L=600n M=1
MM4 S S_BAR VSS VSS nch W=1u L=600n M=1
MM2 CO CO_BAR VSS VSS nch W=1u L=600n M=1
MM3 S_BAR CO_BAR net23 VSS nch W=1u L=600n M=1
RR2 VDD S_BAR 160667
RR1 VDD CO 151000
RR0 VDD CO_BAR 154500
RR3 VDD S 166333
.ENDS
.SUBCKT HA_X2RL_T5 A B CO S VDD VSS
MM5 net23 A VSS VSS nch W=1u L=600n M=1
MM6 net23 B VSS VSS nch W=1u L=600n M=1
MM0 net28 B VSS VSS nch W=1u L=600n M=1
MM1 CO_BAR A net28 VSS nch W=1u L=600n M=1
MM4 S S_BAR VSS VSS nch W=1u L=600n M=1
MM2 CO CO_BAR VSS VSS nch W=1u L=600n M=1
MM3 S_BAR CO_BAR net23 VSS nch W=1u L=600n M=1
RR2 VDD S_BAR 160667
RR1 VDD CO 151000
RR0 VDD CO_BAR 154500
RR3 VDD S 84333.3
.ENDS
.SUBCKT HA_X4RL_T5 A B CO S VDD VSS
MM5 net23 A VSS VSS nch W=1u L=600n M=1
MM6 net23 B VSS VSS nch W=1u L=600n M=1
MM0 net28 B VSS VSS nch W=1u L=600n M=1
MM1 CO_BAR A net28 VSS nch W=1u L=600n M=1
MM4 S S_BAR VSS VSS nch W=1u L=600n M=1
MM2 CO CO_BAR VSS VSS nch W=1u L=600n M=1
MM3 S_BAR CO_BAR net23 VSS nch W=1u L=600n M=1
RR2 VDD S_BAR 154500
RR1 VDD CO 151000
RR0 VDD CO_BAR 154500
RR3 VDD S 40166.7
.ENDS
.SUBCKT INV_X1PC_T5 A VDD VSS Y
RR0 VDD AN 154333
MM1 VDD AN Y VSS nch W=1u L=600n M=1
MM2 Y A VSS VSS nch W=1u L=600n M=1
MM0 AN A VSS VSS nch W=1u L=600n M=1
.ENDS
.SUBCKT INV_X1RL_T5 A VDD VSS Y
RR0 VDD Y 153667
MM0 Y A VSS VSS nch W=1u L=600n M=1
.ENDS
.SUBCKT INV_X2PC_T5 A VDD VSS Y
RR0 VDD AN 154333
MM1 VDD AN Y VSS nch W=2u L=600n M=1
MM2 Y A VSS VSS nch W=2u L=600n M=1
MM0 AN A VSS VSS nch W=1u L=600n M=1
.ENDS
.SUBCKT INV_X2RL_T5 A VDD VSS Y
RR0 VDD Y 87666.7
MM0 Y A VSS VSS nch W=1u L=600n M=1
.ENDS
.SUBCKT INV_X4PC_T5 A VDD VSS Y
RR0 VDD AN 40166.7
MM1 VDD AN Y VSS nch W=4u L=600n M=1
MM2 Y A VSS VSS nch W=4u L=600n M=1
MM0 AN A VSS VSS nch W=4u L=600n M=1
.ENDS
.SUBCKT INV_X4RL_T5 A VDD VSS Y
RR2 VDD Y 40166.7
MM0 Y A VSS VSS nch W=1u L=600n M=1
.ENDS
.SUBCKT LAT_X1PC_T5 D E Q QN VDD VSS
RR0 VDD EN 151000
RR1 VDD ENN 160667
RR3 VDD L 160667
RR2 VDD LN 154333
MM6 VDD LN QN VSS nch W=1u L=600n M=1
MM8 VDD L Q VSS nch W=1u L=600n M=1
MM7 QN L VSS VSS nch W=1u L=600n M=1
MM9 Q LN VSS VSS nch W=1u L=600n M=1
MM2 D ENN D_ VSS nch W=1u L=600n M=1
MM4 LN D_ VSS VSS nch W=1u L=600n M=1
MM3 D_ EN L VSS nch W=1u L=600n M=1
MM5 L LN VSS VSS nch W=1u L=600n M=1
MM1 ENN EN VSS VSS nch W=1u L=600n M=1
MM0 EN E VSS VSS nch W=1u L=600n M=1
.ENDS
.SUBCKT LAT_X2PC_T5 D E Q QN VDD VSS
RR2 VDD LN 87666.7
RR3 VDD L 84000
RR0 VDD EN 151000
RR1 VDD ENN 160667
MM0 EN E VSS VSS nch W=1u L=600n M=1
MM1 ENN EN VSS VSS nch W=1u L=600n M=1
MM5 L LN VSS VSS nch W=1u L=600n M=1
MM3 D_ EN L VSS nch W=1u L=600n M=1
MM4 LN D_ VSS VSS nch W=1u L=600n M=1
MM2 D ENN D_ VSS nch W=1u L=600n M=1
MM9 Q LN VSS VSS nch W=2u L=600n M=1
MM7 QN L VSS VSS nch W=2u L=600n M=1
MM8 VDD L Q VSS nch W=2u L=600n M=1
MM6 VDD LN QN VSS nch W=2u L=600n M=1
.ENDS
.SUBCKT LAT_X4PC_T5 D E Q QN VDD VSS
RR1 VDD ENN 160667
RR0 VDD EN 151000
RR3 VDD L 40166.7
RR2 VDD LN 40166.7
MM6 VDD LN QN VSS nch W=4u L=600n M=1
MM8 VDD L Q VSS nch W=4u L=600n M=1
MM7 QN L VSS VSS nch W=4u L=600n M=1
MM9 Q LN VSS VSS nch W=4u L=600n M=1
MM2 D ENN D_ VSS nch W=1u L=600n M=1
MM4 LN D_ VSS VSS nch W=1u L=600n M=1
MM3 D_ EN L VSS nch W=1u L=600n M=1
MM5 L LN VSS VSS nch W=1u L=600n M=1
MM1 ENN EN VSS VSS nch W=1u L=600n M=1
MM0 EN E VSS VSS nch W=1u L=600n M=1
.ENDS
.SUBCKT MX2_X1RL_T5 A B S VDD VSS Y
RR0 VDD Sbar 160667
RR2 VDD Y 158333
RR1 VDD Xbar 158333
MM5 Sbar S VSS VSS nch W=1u L=600n M=1
MM4 net18 S VSS VSS nch W=1u L=600n M=1
MM3 net19 Sbar VSS VSS nch W=1u L=600n M=1
MM2 Y Xbar VSS VSS nch W=1u L=600n M=1
MM1 Xbar B net18 VSS nch W=1u L=600n M=1
MM0 Xbar A net19 VSS nch W=1u L=600n M=1
.ENDS
.SUBCKT MX2_X2RL_T5 A B S VDD VSS Y
RR0 VDD Sbar 160667
RR2 VDD Y 90333.3
RR1 VDD Xbar 158333
MM5 Sbar S VSS VSS nch W=1u L=600n M=1
MM4 net18 S VSS VSS nch W=1u L=600n M=1
MM3 net19 Sbar VSS VSS nch W=1u L=600n M=1
MM2 Y Xbar VSS VSS nch W=1u L=600n M=1
MM1 Xbar B net18 VSS nch W=1u L=600n M=1
MM0 Xbar A net19 VSS nch W=1u L=600n M=1
.ENDS
.SUBCKT MX2_X4RL_T5 A B S VDD VSS Y
RR0 VDD Sbar 160667
RR2 VDD Y 43666.7
RR1 VDD Xbar 158333
MM5 Sbar S VSS VSS nch W=1u L=600n M=1
MM4 net18 S VSS VSS nch W=1u L=600n M=1
MM3 net19 Sbar VSS VSS nch W=1u L=600n M=1
MM2 Y Xbar VSS VSS nch W=1u L=600n M=1
MM1 Xbar B net18 VSS nch W=1u L=600n M=1
MM0 Xbar A net19 VSS nch W=1u L=600n M=1
.ENDS
.SUBCKT MXI2_X1RL_T5 A B S VDD VSS Y
RR0 VDD Sbar 155000
RR1 VDD Y 154333
MM5 Sbar S VSS VSS nch W=1u L=600n M=1
MM4 net18 S VSS VSS nch W=1u L=600n M=1
MM3 net19 Sbar VSS VSS nch W=1u L=600n M=1
MM1 Y B net18 VSS nch W=1u L=600n M=1
MM0 Y A net19 VSS nch W=1u L=600n M=1
.ENDS
.SUBCKT MXI2_X2RL_T5 A B S VDD VSS Y
RR0 VDD Sbar 154167
RR1 VDD Y 80333.3
MM5 Sbar S VSS VSS nch W=1u L=600n M=1
MM4 net18 S VSS VSS nch W=1u L=600n M=1
MM3 net19 Sbar VSS VSS nch W=1u L=600n M=1
MM1 Y B net18 VSS nch W=1u L=600n M=1
MM0 Y A net19 VSS nch W=1u L=600n M=1
.ENDS
.SUBCKT MXI2_X4RL_T5 A B S VDD VSS Y
RR0 VDD Sbar 155167
RR1 VDD Y 40166.7
MM5 Sbar S VSS VSS nch W=1u L=600n M=1
MM4 net18 S VSS VSS nch W=2u L=600n M=1
MM3 net19 Sbar VSS VSS nch W=2u L=600n M=1
MM1 Y B net18 VSS nch W=2u L=600n M=1
MM0 Y A net19 VSS nch W=2u L=600n M=1
.ENDS
.SUBCKT NAND2_X0P7RL_T5 A1 A2 VDD VSS Y
RR0 VDD Y 220333
MM1 net12 A2 VSS VSS nch W=1u L=600n M=1
MM0 Y A1 net12 VSS nch W=1u L=600n M=1
.ENDS
.SUBCKT NAND2_X1RL_T5 A1 A2 VDD VSS Y
RR0 VDD Y 161667
MM1 net12 A2 VSS VSS nch W=1u L=600n M=1
MM0 Y A1 net12 VSS nch W=1u L=600n M=1
.ENDS
.SUBCKT NAND2_X2RL_T5 A1 A2 VDD VSS Y
RR0 VDD Y 80833.3
MM0 Y A1 M0_S_M1_D VSS nch W=1u L=600n M=1
MM1 M0_S_M1_D A2 VSS VSS nch W=1u L=600n M=1
.ENDS
.SUBCKT NAND2_X4RL_T5 A1 A2 VDD VSS Y
RR0 VDD Y 48333.3
MM0 Y A1 M0_S_M1_D VSS nch W=2u L=600n M=1
MM1 M0_S_M1_D A2 VSS VSS nch W=2u L=600n M=1
.ENDS
.SUBCKT NAND3_X1RL_T5 A1 A2 A3 VDD VSS Y
RR0 VDD Y 154500
MM2 net14 A3 VSS VSS nch W=1u L=600n M=1
MM0 Y A1 net15 VSS nch W=1u L=600n M=1
MM1 net15 A2 net14 VSS nch W=1u L=600n M=1
.ENDS
.SUBCKT NAND3_X2RL_T5 A1 A2 A3 VDD VSS Y
RR0 VDD Y 80833.3
MM2 net14 A3 VSS VSS nch W=1u L=600n M=1
MM0 Y A1 net15 VSS nch W=1u L=600n M=1
MM1 net15 A2 net14 VSS nch W=1u L=600n M=1
.ENDS
.SUBCKT NAND3_X4RL_T5 A1 A2 A3 VDD VSS Y
RR0 VDD Y 46666.7
MM2 net14 A3 VSS VSS nch W=2u L=600n M=1
MM0 Y A1 net15 VSS nch W=2u L=600n M=1
MM1 net15 A2 net14 VSS nch W=2u L=600n M=1
.ENDS
.SUBCKT NAND4_X1RL_T5 A1 A2 A3 A4 VDD VSS Y
RR0 VDD Y 154500
MM3 net09 A4 VSS VSS nch W=1u L=600n M=1
MM2 net14 A3 net09 VSS nch W=1u L=600n M=1
MM0 Y A1 net15 VSS nch W=1u L=600n M=1
MM1 net15 A2 net14 VSS nch W=1u L=600n M=1
.ENDS
.SUBCKT NAND4_X2RL_T5 A1 A2 A3 A4 VDD VSS Y
RR0 VDD Y 80833.3
MM3 net09 A4 VSS VSS nch W=2u L=600n M=1
MM2 net14 A3 net09 VSS nch W=2u L=600n M=1
MM0 Y A1 net15 VSS nch W=2u L=600n M=1
MM1 net15 A2 net14 VSS nch W=2u L=600n M=1
.ENDS
.SUBCKT NOR2_X1RL_T5 A1 A2 VDD VSS Y
RR0 VDD Y 158333
MM1 Y A2 VSS VSS nch W=1u L=600n M=1
MM0 Y A1 VSS VSS nch W=1u L=600n M=1
.ENDS
.SUBCKT NOR2_X2RL_T5 A1 A2 VDD VSS Y
RR0 VDD Y 80666.7
MM1 Y A2 VSS VSS nch W=1u L=600n M=1
MM0 Y A1 VSS VSS nch W=1u L=600n M=1
.ENDS
.SUBCKT NOR2_X4RL_T5 A1 A2 VDD VSS Y
RR0 VDD Y 40333.3
MM1 Y A2 VSS VSS nch W=1u L=600n M=1
MM0 Y A1 VSS VSS nch W=1u L=600n M=1
.ENDS
.SUBCKT NOR3_X1RL_T5 A1 A2 A3 VDD VSS Y
RR0 VDD Y 154500
MM2 Y A3 VSS VSS nch W=1u L=600n M=1
MM0 Y A1 VSS VSS nch W=1u L=600n M=1
MM1 Y A2 VSS VSS nch W=1u L=600n M=1
.ENDS
.SUBCKT NOR3_X2RL_T5 A1 A2 A3 VDD VSS Y
RR0 VDD Y 77333.3
MM0 Y A1 VSS VSS nch W=1u L=600n M=1
MM1 Y A2 VSS VSS nch W=1u L=600n M=1
MM2 Y A3 VSS VSS nch W=1u L=600n M=1
.ENDS
.SUBCKT NOR3_X4RL_T5 A1 A2 A3 VDD VSS Y
RR0 VDD Y 41833.3
MM0 Y A1 VSS VSS nch W=1u L=600n M=1
MM1 Y A2 VSS VSS nch W=1u L=600n M=1
MM2 Y A3 VSS VSS nch W=1u L=600n M=1
.ENDS
.SUBCKT NOR4_X1RL_T5 A1 A2 A3 A4 VDD VSS Y
RR0 VDD Y 154833
MM3 Y A4 VSS VSS nch W=1u L=600n M=1
MM2 Y A3 VSS VSS nch W=1u L=600n M=1
MM0 Y A1 VSS VSS nch W=1u L=600n M=1
MM1 Y A2 VSS VSS nch W=1u L=600n M=1
.ENDS
.SUBCKT NOR4_X2RL_T5 A1 A2 A3 A4 VDD VSS Y
RR0 VDD Y 77333.3
MM3 Y A4 VSS VSS nch W=1u L=600n M=1
MM2 Y A3 VSS VSS nch W=1u L=600n M=1
MM0 Y A1 VSS VSS nch W=1u L=600n M=1
MM1 Y A2 VSS VSS nch W=1u L=600n M=1
.ENDS
.SUBCKT NOR4_X4RL_T5 A1 A2 A3 A4 VDD VSS Y
RR0 VDD Y 40166.7
MM3 Y A4 VSS VSS nch W=1u L=600n M=1
MM2 Y A3 VSS VSS nch W=1u L=600n M=1
MM0 Y A1 VSS VSS nch W=1u L=600n M=1
MM1 Y A2 VSS VSS nch W=1u L=600n M=1
.ENDS
.SUBCKT OAI211_X1RL_T5 A1 A2 B C VDD VSS Y
MM3 M0_S_M1_D A2 VSS VSS nch W=1u L=600n M=1
MM2 M0_S_M1_D A1 VSS VSS nch W=1u L=600n M=1
MM1 net27 B M0_S_M1_D VSS nch W=1u L=600n M=1
MM0 Y C net27 VSS nch W=1u L=600n M=1
RR0 VDD Y 148000
.ENDS
.SUBCKT OAI211_X2RL_T5 A1 A2 B C VDD VSS Y
MM3 M0_S_M1_D A2 VSS VSS nch W=1u L=600n M=1
MM2 M0_S_M1_D A1 VSS VSS nch W=1u L=600n M=1
MM1 net27 B M0_S_M1_D VSS nch W=1u L=600n M=1
MM0 Y C net27 VSS nch W=1u L=600n M=1
RR0 VDD Y 80833.3
.ENDS
.SUBCKT OAI211_X4RL_T5 A1 A2 B C VDD VSS Y
MM3 M0_S_M1_D A2 VSS VSS nch W=2u L=600n M=1
MM2 M0_S_M1_D A1 VSS VSS nch W=2u L=600n M=1
MM1 net27 B M0_S_M1_D VSS nch W=2u L=600n M=1
MM0 Y C net27 VSS nch W=2u L=600n M=1
RR0 VDD Y 40333.3
.ENDS
.SUBCKT OAI21_X1RL_T5 A1 A2 B VDD VSS Y
RR0 VDD Y 148000
MM2 M0_S_M1_D A2 VSS VSS nch W=1u L=600n M=1
MM0 Y B M0_S_M1_D VSS nch W=1u L=600n M=1
MM1 M0_S_M1_D A1 VSS VSS nch W=1u L=600n M=1
.ENDS
.SUBCKT OAI21_X2RL_T5 A1 A2 B VDD VSS Y
RR0 VDD Y 80333.3
MM2 M0_S_M1_D A2 VSS VSS nch W=1u L=600n M=1
MM0 Y B M0_S_M1_D VSS nch W=1u L=600n M=1
MM1 M0_S_M1_D A1 VSS VSS nch W=1u L=600n M=1
.ENDS
.SUBCKT OAI21_X4RL_T5 A1 A2 B VDD VSS Y
RR0 VDD Y 40333.3
MM2 M0_S_M1_D A2 VSS VSS nch W=1u L=600n M=1
MM0 Y B M0_S_M1_D VSS nch W=1u L=600n M=1
MM1 M0_S_M1_D A1 VSS VSS nch W=1u L=600n M=1
.ENDS
.SUBCKT OAI22_X1RL_T5 A1 A2 B1 B2 VDD VSS Y
RR0 VDD Y 155000
MM3 Y B2 net2 VSS nch W=1u L=600n M=1
MM2 net2 A2 VSS VSS nch W=1u L=600n M=1
MM1 net2 A1 VSS VSS nch W=1u L=600n M=1
MM0 Y B1 net2 VSS nch W=1u L=600n M=1
.ENDS
.SUBCKT OAI22_X2RL_T5 A1 A2 B1 B2 VDD VSS Y
RR0 VDD Y 80833.3
MM3 Y B2 net2 VSS nch W=1u L=600n M=1
MM2 net2 A2 VSS VSS nch W=1u L=600n M=1
MM1 net2 A1 VSS VSS nch W=1u L=600n M=1
MM0 Y B1 net2 VSS nch W=1u L=600n M=1
.ENDS
.SUBCKT OAI22_X4RL_T5 A1 A2 B1 B2 VDD VSS Y
RR0 VDD Y 40333.3
MM3 Y B2 net2 VSS nch W=1u L=600n M=1
MM2 net2 A2 VSS VSS nch W=1u L=600n M=1
MM1 net2 A1 VSS VSS nch W=1u L=600n M=1
MM0 Y B1 net2 VSS nch W=1u L=600n M=1
.ENDS
.SUBCKT OR2_X1RL_T5 A1 A2 VDD VSS Y
RR1 VDD Y 151000
RR0 VDD net6 154500
MM2 Y net6 VSS VSS nch W=1u L=600n M=1
MM0 net6 A1 VSS VSS nch W=1u L=600n M=1
MM1 net6 A2 VSS VSS nch W=1u L=600n M=1
.ENDS
.SUBCKT OR2_X2RL_T5 A1 A2 VDD VSS Y
RR1 VDD Y 80833.3
RR0 VDD net6 151667
MM2 Y net6 VSS VSS nch W=1u L=600n M=1
MM0 net6 A1 VSS VSS nch W=1u L=600n M=1
MM1 net6 A2 VSS VSS nch W=1u L=600n M=1
.ENDS
.SUBCKT OR2_X4RL_T5 A1 A2 VDD VSS Y
RR1 VDD Y 40166.7
RR0 VDD net6 151667
MM2 Y net6 VSS VSS nch W=1u L=600n M=1
MM0 net6 A1 VSS VSS nch W=1u L=600n M=1
MM1 net6 A2 VSS VSS nch W=1u L=600n M=1
.ENDS
.SUBCKT OR3_X1RL_T5 A1 A2 A3 VDD VSS Y
RR1 VDD Y 164333
RR0 VDD net6 154333
MM2 Y net6 VSS VSS nch W=1u L=600n M=1
MM3 net6 A2 VSS VSS nch W=1u L=600n M=1
MM0 net6 A1 VSS VSS nch W=1u L=600n M=1
MM1 net6 A3 VSS VSS nch W=1u L=600n M=1
.ENDS
.SUBCKT OR3_X2RL_T5 A1 A2 A3 VDD VSS Y
RR3 VDD Y 84333.3
RR0 VDD net6 154500
MM2 Y net6 VSS VSS nch W=1u L=600n M=1
MM3 net6 A2 VSS VSS nch W=1u L=600n M=1
MM0 net6 A1 VSS VSS nch W=1u L=600n M=1
MM1 net6 A3 VSS VSS nch W=1u L=600n M=1
.ENDS
.SUBCKT OR3_X4RL_T5 A1 A2 A3 VDD VSS Y
RR4 VDD Y 40000
RR0 VDD net6 154500
MM2 Y net6 VSS VSS nch W=1u L=600n M=1
MM3 net6 A2 VSS VSS nch W=1u L=600n M=1
MM0 net6 A1 VSS VSS nch W=1u L=600n M=1
MM1 net6 A3 VSS VSS nch W=1u L=600n M=1
.ENDS
.SUBCKT OR4_X1RL_T5 A1 A2 A3 A4 VDD VSS Y
RR2 VDD Y 154333
RR0 VDD net6 154333
MM4 net6 A4 VSS VSS nch W=1u L=600n M=1
MM2 Y net6 VSS VSS nch W=1u L=600n M=1
MM3 net6 A2 VSS VSS nch W=1u L=600n M=1
MM0 net6 A1 VSS VSS nch W=1u L=600n M=1
MM1 net6 A3 VSS VSS nch W=1u L=600n M=1
.ENDS
.SUBCKT OR4_X2RL_T5 A1 A2 A3 A4 VDD VSS Y
RR2 VDD Y 87666.7
RR0 VDD net6 154500
MM4 net6 A4 VSS VSS nch W=1u L=600n M=1
MM2 Y net6 VSS VSS nch W=1u L=600n M=1
MM3 net6 A2 VSS VSS nch W=1u L=600n M=1
MM0 net6 A1 VSS VSS nch W=1u L=600n M=1
MM1 net6 A3 VSS VSS nch W=1u L=600n M=1
.ENDS
.SUBCKT OR4_X4RL_T5 A1 A2 A3 A4 VDD VSS Y
RR2 VDD Y 40000
RR0 VDD net6 154500
MM4 net6 A4 VSS VSS nch W=1u L=600n M=1
MM2 Y net6 VSS VSS nch W=1u L=600n M=1
MM3 net6 A2 VSS VSS nch W=1u L=600n M=1
MM0 net6 A1 VSS VSS nch W=1u L=600n M=1
MM1 net6 A3 VSS VSS nch W=1u L=600n M=1
.ENDS
.SUBCKT TIEHI_T5 VDD VSS Y
RR0 VDD Y 3250
.ENDS
.SUBCKT TIELO_T5 VDD VSS Y
RR0 Y VSS 3250
.ENDS
.SUBCKT XNOR2_X1RL_T5 A1 A2 VDD VSS Y
MM5 net16 A2 VSS VSS nch W=1u L=600n M=1
MM4 Y A1bar net16 VSS nch W=1u L=600n M=1
MM3 net17 A1 VSS VSS nch W=1u L=600n M=1
MM2 Y A2bar net17 VSS nch W=1u L=600n M=1
MM1 A2bar A2 VSS VSS nch W=1u L=600n M=1
MM0 A1bar A1 VSS VSS nch W=1u L=600n M=1
RR5 VDD A1bar 148333
RR4 VDD Y 148333
RR3 VDD A2bar 154500
.ENDS
.SUBCKT XNOR2_X2RL_T5 A1 A2 VDD VSS Y
MM0 A1N A1 VSS VSS nch W=1u L=600n M=1
MM1 A2N A2 VSS VSS nch W=1u L=600n M=1
MM2 Y A2N net1 VSS nch W=1u L=600n M=1
MM3 net1 A1 VSS VSS nch W=1u L=600n M=1
MM4 Y A1N net2 VSS nch W=1u L=600n M=1
MM5 net2 A2 VSS VSS nch W=1u L=600n M=1
RR0 VDD A1N 148333
RR1 VDD A2N 148500
RR2 VDD Y 81333.3
.ENDS
.SUBCKT XNOR2_X4RL_T5 A1 A2 VDD VSS Y
MM5 net16 A2 VSS VSS nch W=2u L=600n M=1
MM4 Y A1N net16 VSS nch W=2u L=600n M=1
MM3 net15 A1 VSS VSS nch W=2u L=600n M=1
MM2 Y A2N net15 VSS nch W=2u L=600n M=1
MM1 A2N A2 VSS VSS nch W=1u L=600n M=1
MM0 A1N A1 VSS VSS nch W=1u L=600n M=1
RR2 VDD Y 46333.3
RR1 VDD A2N 148333
RR0 VDD A1N 148333
.ENDS
.SUBCKT XOR2_X1RL_T5 A1 A2 VDD VSS Y
RR2 VDD Y 148333
RR1 VDD A2N 151000
RR0 VDD A1N 142333
MM2 Y A2 net2 VSS nch W=1u L=600n M=1
MM4 Y A2N net1 VSS nch W=1u L=600n M=1
MM3 net2 A1 VSS VSS nch W=1u L=600n M=1
MM5 net1 A1N VSS VSS nch W=1u L=600n M=1
MM1 A2N A2 VSS VSS nch W=1u L=600n M=1
MM0 A1N A1 VSS VSS nch W=1u L=600n M=1
.ENDS
.SUBCKT XOR2_X2RL_T5 A1 A2 VDD VSS Y
RR4 VDD A2N 151000
RR3 VDD A1N 142333
RR2 VDD Y 76666.7
MM0 A1N A1 VSS VSS nch W=1u L=600n M=1
MM1 A2N A2 VSS VSS nch W=1u L=600n M=1
MM5 net2 A1N VSS VSS nch W=1u L=600n M=1
MM3 net1 A1 VSS VSS nch W=1u L=600n M=1
MM4 Y A2N net2 VSS nch W=1u L=600n M=1
MM2 Y A2 net1 VSS nch W=1u L=600n M=1
.ENDS
.SUBCKT XOR2_X4RL_T5 A1 A2 VDD VSS Y
RR2 VDD Y 39166.7
RR0 VDD A1N 142333
RR1 VDD A2N 151000
MM2 Y A2 net1 VSS nch W=2u L=600n M=1
MM4 Y A2N net2 VSS nch W=2u L=600n M=1
MM3 net1 A1 VSS VSS nch W=2u L=600n M=1
MM5 net2 A1N VSS VSS nch W=2u L=600n M=1
MM1 A2N A2 VSS VSS nch W=1u L=600n M=1
MM0 A1N A1 VSS VSS nch W=1u L=600n M=1
.ENDS
