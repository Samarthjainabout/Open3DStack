* DC transfer sweep for the neutral 3D_TFT n-channel primitive.
.include pdk/tft3d_platform/libs.tech/ngspice/tft3d_platform_primitives.spice

Vd d 0 0.1
Vg g 0 0
Vs s 0 0
M0 d g s 0 nch W=20u L=5u

.dc Vg -3 3.3 0.1
.control
run
wrdata pdk/tft3d_platform/libs.tech/ngspice/examples/dc_transfer_nch.dat v(g) i(vd)
quit
.endc
.end
